** sch_path: /foss/designs/PhaseInterpolator/BinarytoThermo/3to7_deco_v2.sch
.subckt 3to7_deco_v2 ST[7] ST[6] ST[5] ST[4] ST[3] ST[2] ST[1] S[2] S[1] S[0] VDD VSS
*.PININFO ST[7:1]:O S[2:0]:I VDD:B VSS:B
x1 VDD net3 S[2] VSS inv
x2 VDD net2 S[1] VSS inv
x3 VDD net1 S[0] VSS inv
x4 VDD net1 net2 net3 ST[1] VSS nor_x3_custom
x5 VDD net2 ST[2] net3 VSS nor_custom
x6 VDD net5 ST[3] net3 VSS nor_custom
x7 VDD ST[4] net3 VSS inv
x8 VDD ST[5] net4 net3 VSS nand_custom
x9 VDD ST[6] net2 net3 VSS nand_custom
x11 VDD net5 net2 net1 VSS and_custom
x12 VDD net1 net4 net2 VSS or_custom
x10 VDD ST[7] net1 net2 net3 VSS nand_x3_custom
.ends

* expanding   symbol:  /foss/designs/PhaseInterpolator/Custom_std_cells/inv.sym # of pins=4
** sym_path: /foss/designs/PhaseInterpolator/Custom_std_cells/inv.sym
** sch_path: /foss/designs/PhaseInterpolator/Custom_std_cells/inv.sch
.subckt inv VDD VOUT VIN VSS
*.PININFO VDD:B VSS:B VOUT:O VIN:I
M2 VOUT VIN VDD VDD sg13_lv_pmos w=0.15u l=0.13u ng=1 m=1
M1 VOUT VIN VSS VSS sg13_lv_nmos w=0.15u l=0.13u ng=1 m=1
.ends

* expanding   symbol:  /foss/designs/PhaseInterpolator/Custom_std_cells/nor_x3_custom.sym # of pins=6
** sym_path: /foss/designs/PhaseInterpolator/Custom_std_cells/nor_x3_custom.sym
** sch_path: /foss/designs/PhaseInterpolator/Custom_std_cells/nor_x3_custom.sch
.subckt nor_x3_custom VDD A B C OUT VSS
*.PININFO VDD:B VSS:B B:I C:I OUT:O A:I
M1 OUT A VSS VSS sg13_lv_nmos w=0.15u l=0.13u ng=1 m=1
M2 OUT C net1 VDD sg13_lv_pmos w=0.15u l=0.13u ng=1 m=1
M3 OUT B VSS VSS sg13_lv_nmos w=0.15u l=0.13u ng=1 m=1
M4 net1 B net2 VDD sg13_lv_pmos w=0.15u l=0.13u ng=1 m=1
M5 net2 A VDD VDD sg13_lv_pmos w=0.15u l=0.13u ng=1 m=1
M6 OUT C VSS VSS sg13_lv_nmos w=0.15u l=0.13u ng=1 m=1
.ends

* expanding   symbol:  /foss/designs/PhaseInterpolator/Custom_std_cells/nor_custom.sym # of pins=5
** sym_path: /foss/designs/PhaseInterpolator/Custom_std_cells/nor_custom.sym
** sch_path: /foss/designs/PhaseInterpolator/Custom_std_cells/nor_custom.sch
.subckt nor_custom VDD A OUT B VSS
*.PININFO VDD:B VSS:B A:I B:I OUT:O
M1 OUT A VSS VSS sg13_lv_nmos w=0.15u l=0.13u ng=1 m=1
M2 OUT B net1 VDD sg13_lv_pmos w=0.15u l=0.13u ng=1 m=1
M3 OUT B VSS VSS sg13_lv_nmos w=0.15u l=0.13u ng=1 m=1
M4 net1 A VDD VDD sg13_lv_pmos w=0.15u l=0.13u ng=1 m=1
.ends

* expanding   symbol:  /foss/designs/PhaseInterpolator/Custom_std_cells/nand_custom.sym # of pins=5
** sym_path: /foss/designs/PhaseInterpolator/Custom_std_cells/nand_custom.sym
** sch_path: /foss/designs/PhaseInterpolator/Custom_std_cells/nand_custom.sch
.subckt nand_custom VDD OUT A B VSS
*.PININFO VDD:B VSS:B A:I B:I OUT:O
M1 OUT A net1 VSS sg13_lv_nmos w=0.15u l=0.13u ng=1 m=1
M2 OUT A VDD VDD sg13_lv_pmos w=0.15u l=0.13u ng=1 m=1
M3 net1 B VSS VSS sg13_lv_nmos w=0.15u l=0.13u ng=1 m=1
M4 OUT B VDD VDD sg13_lv_pmos w=0.15u l=0.13u ng=1 m=1
.ends

* expanding   symbol:  /foss/designs/PhaseInterpolator/Custom_std_cells/and_custom.sym # of pins=5
** sym_path: /foss/designs/PhaseInterpolator/Custom_std_cells/and_custom.sym
** sch_path: /foss/designs/PhaseInterpolator/Custom_std_cells/and_custom.sch
.subckt and_custom VDD OUT A B VSS
*.PININFO A:I VDD:B OUT:O VSS:B B:I
x1 VDD OUT net1 VSS inv
x2 VDD net1 A B VSS nand_custom
.ends

* expanding   symbol:  /foss/designs/PhaseInterpolator/Custom_std_cells/or_custom.sym # of pins=5
** sym_path: /foss/designs/PhaseInterpolator/Custom_std_cells/or_custom.sym
** sch_path: /foss/designs/PhaseInterpolator/Custom_std_cells/or_custom.sch
.subckt or_custom VDD A OUT B VSS
*.PININFO VDD:B VSS:B OUT:O A:I B:I
x1 VDD A net1 B VSS nor_custom
x2 VDD OUT net1 VSS inv
.ends

* expanding   symbol:  /foss/designs/PhaseInterpolator/Custom_std_cells/nand_x3_custom.sym # of pins=6
** sym_path: /foss/designs/PhaseInterpolator/Custom_std_cells/nand_x3_custom.sym
** sch_path: /foss/designs/PhaseInterpolator/Custom_std_cells/nand_x3_custom.sch
.subckt nand_x3_custom VDD OUT A B C VSS
*.PININFO A:I B:I C:I VSS:B VDD:B OUT:O
M2 OUT A VDD VDD sg13_lv_pmos w=0.15u l=0.13u ng=1 m=1
M1 OUT B VDD VDD sg13_lv_pmos w=0.15u l=0.13u ng=1 m=1
M3 OUT C VDD VDD sg13_lv_pmos w=0.15u l=0.13u ng=1 m=1
M4 OUT A net1 VSS sg13_lv_nmos w=0.15u l=0.13u ng=1 m=1
M5 net1 B net2 VSS sg13_lv_nmos w=0.15u l=0.13u ng=1 m=1
M6 net2 C VSS VSS sg13_lv_nmos w=0.15u l=0.13u ng=1 m=1
.ends
