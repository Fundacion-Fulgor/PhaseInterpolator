** sch_path: /foss/designs/PhaseInterpolator/BinarytoThermo/tb_3to7_deco_tran.sch
**.subckt tb_3to7_deco_tran
V7 VS[0] VSS PULSE({a*1.2} {d*1.2} 250PS 2PS 2PS 500PS)
V1 VS[1] VSS PULSE({b*1.2} {d*1.2} 250PS 2PS 2PS 500PS)
V2 VS[2] VSS PULSE({c*1.2} {d*1.2} 250PS 2PS 2PS 500PS)
V3 VSS GND DC{VSS}
V4 VDD VSS DC{VDD}
x1 vo_st7 vo_st6 vo_st5 vo_st4 vo_st3 vo_st2 vo_st1 VS[2] VS[1] VS[0] VDD VSS 3to7_deco
x4[6] VDD net1_6 vo_st7 VSS inv
x4[5] VDD net1_5 vo_st6 VSS inv
x4[4] VDD net1_4 vo_st5 VSS inv
x4[3] VDD net1_3 vo_st4 VSS inv
x4[2] VDD net1_2 vo_st3 VSS inv
x4[1] VDD net1_1 vo_st2 VSS inv
x4[0] VDD net1_0 vo_st1 VSS inv
C3[6] net1_6 VSS 1p m=1
C3[5] net1_5 VSS 1p m=1
C3[4] net1_4 VSS 1p m=1
C3[3] net1_3 VSS 1p m=1
C3[2] net1_2 VSS 1p m=1
C3[1] net1_1 VSS 1p m=1
C3[0] net1_0 VSS 1p m=1
**** begin user architecture code

* Circuit Parameters
.param vdd = 1.2
.param vss = 0.0
.param a=0
.param b=0
.param c=0
.param d=1
.param Tclk = 500P
.options TEMP = 65.0

* Include Models
.lib /foss/pdks/ihp-sg13g2/libs.tech/ngspice/models/cornerMOSlv.lib mos_tt
cornerMOSlv.lib mos_tt
cornerMOShv.lib mos_tt
cornerHBT.lib hbt_typ
cornerRES.lib res_typ

* OP Parameters & Singals to save
.save all

*Simulations
.control
set output_path = tb_bin2thermo_tran/

* --- ESTADO 1: Entrada 001 (Salida T1 activa) ---
alterparam a=0 b=0 c=1
reset
tran 0.2PS 500PS
setplot tran1
plot vo_st7 ylabel Vout xlabel Vin
set filetype =ascii
write {$output_path}out1.raw V(vo_st7)

* --- ESTADO 2: Entrada 010 (Salidas T1, T2 activas) ---
alterparam a=0 b=1 c=0
reset
tran 0.2PS 500PS
setplot tran2
plot vo_st7 vo_st6 ylabel Vout xlabel Vin
set filetype =ascii
write {$output_path}out2.raw V(vo_st7) V(vo_st6)

* --- ESTADO 3: Entrada 011 (Salidas T1, T2, T3 activas) ---
alterparam a=0 b=1 c=1
reset
tran 0.2PS 500PS
setplot tran3
plot vo_st7 vo_st6 vo_st5 ylabel Vout xlabel Vin
set filetype =ascii
write {$output_path}out3.raw V(vo_st7) V(vo_st6) V(vo_st5)

* --- ESTADO 4: Entrada 100 (Salidas T1 a T4 activas) ---
alterparam a=1 b=0 c=0
reset
tran 0.2PS 500PS
setplot tran4
plot  vo_st7 vo_st6 vo_st5 vo_st4 ylabel Vout xlabel Vin
set filetype =ascii
write {$output_path}out4.raw V(vo_st7) V(vo_st6) V(vo_st5) V(vo_st4)

* --- ESTADO 5: Entrada 101 (Salidas T1 a T5 activas) ---
alterparam a=1 b=0 c=1
reset
tran 0.2PS 500PS
setplot tran5
plot vo_st7 vo_st6 vo_st5 vo_st4 vo_st3 ylabel Vout xlabel Vin
set filetype =ascii
write {$output_path}out5.raw V(vo_st7) V(vo_st6) V(vo_st5) V(vo_st4) V(vo_st3)

* --- ESTADO 6: Entrada 110 (Salidas T1 a T6 activas) ---
alterparam a=1 b=1 c=0
reset
tran 0.2PS 500PS
setplot tran6
plot vo_st7 vo_st6 vo_st5 vo_st4 vo_st3 vo_st2 ylabel Vout xlabel Vin
set filetype =ascii
write {$output_path}out6.raw V(vo_st7) V(vo_st6) V(vo_st5) V(vo_st4) V(vo_st3) V(vo_st2)

* --- ESTADO 7: Entrada 111 (Salidas T1 a T7 activas) ---
alterparam a=1 b=1 c=1
reset
tran 0.2PS 500PS
setplot tran7
plot vo_st7 vo_st6 vo_st5 vo_st4 vo_st3 vo_st2 vo_st1 ylabel Vout xlabel Vin
set filetype =ascii
write {$output_path}out7.raw V(vo_st7) V(vo_st6) V(vo_st5) V(vo_st4) V(vo_st3) V(vo_st2) V(vo_st1)
.endc
.end

**** end user architecture code
**.ends

* expanding   symbol:  3to7_deco.sym # of pins=4
** sym_path: /foss/designs/PhaseInterpolator/BinarytoThermo/3to7_deco.sym
** sch_path: /foss/designs/PhaseInterpolator/BinarytoThermo/3to7_deco.sch
.subckt 3to7_deco ST[7] ST[6] ST[5] ST[4] ST[3] ST[2] ST[1] S[2] S[1] S[0] VDD VSS
*.iopin VDD
*.iopin VSS
*.opin ST[7],ST[6],ST[5],ST[4],ST[3],ST[2],ST[1]
*.ipin S[2],S[1],S[0]
x1 VDD ST[2] S[0] S[1] VSS and_custom
x2 VDD S[0] ST[1] S[1] S[2] VSS and_x3_custom
x3 VDD net1 ST[3] net2 VSS or_custom
x4 VDD net1 S[0] S[1] VSS and_custom
x5 VDD net2 S[0] S[2] VSS and_custom
x6 VDD net3 ST[5] S[0] VSS or_custom
x7 VDD net3 S[1] S[2] VSS and_custom
x8 VDD S[0] ST[6] S[1] VSS or_custom
x9 VDD S[0] ST[7] S[1] S[2] VSS or_x3_custom
x10 VDD net4 S[0] VSS inv
x11 VDD ST[4] net4 VSS inv
.ends

* expanding   symbol:  /foss/designs/PhaseInterpolator/Custom_std_cells/inv.sym # of pins=4
** sym_path: /foss/designs/PhaseInterpolator/Custom_std_cells/inv.sym
** sch_path: /foss/designs/PhaseInterpolator/Custom_std_cells/inv.sch
.subckt inv VDD VOUT VIN VSS
*.iopin VDD
*.iopin VSS
*.opin VOUT
*.ipin VIN
XM2 VOUT VIN VDD VDD sg13_lv_pmos w=0.15u l=0.13u ng=1 m=3
XM1 VOUT VIN VSS VSS sg13_lv_nmos w=0.15u l=0.13u ng=1 m=2
.ends

* expanding   symbol:  /foss/designs/PhaseInterpolator/Custom_std_cells/and_custom.sym # of pins=5
** sym_path: /foss/designs/PhaseInterpolator/Custom_std_cells/and_custom.sym
** sch_path: /foss/designs/PhaseInterpolator/Custom_std_cells/and_custom.sch
.subckt and_custom VDD OUT A B VSS
*.ipin A
*.iopin VDD
*.opin OUT
*.iopin VSS
*.ipin B
x1 VDD OUT net1 VSS inv
x2 VDD net1 A B VSS nand_custom
.ends

* expanding   symbol:  /foss/designs/PhaseInterpolator/Custom_std_cells/and_x3_custom.sym # of pins=6
** sym_path: /foss/designs/PhaseInterpolator/Custom_std_cells/and_x3_custom.sym
** sch_path: /foss/designs/PhaseInterpolator/Custom_std_cells/and_x3_custom.sch
.subckt and_x3_custom VDD A OUT B C VSS
*.iopin VDD
*.iopin VSS
*.ipin A
*.ipin B
*.ipin C
*.opin OUT
x1 VDD net1 A B C VSS nand_x3_custom
x2 VDD OUT net1 VSS inv
.ends

* expanding   symbol:  /foss/designs/PhaseInterpolator/Custom_std_cells/or_custom.sym # of pins=5
** sym_path: /foss/designs/PhaseInterpolator/Custom_std_cells/or_custom.sym
** sch_path: /foss/designs/PhaseInterpolator/Custom_std_cells/or_custom.sch
.subckt or_custom VDD A OUT B VSS
*.iopin VDD
*.iopin VSS
*.opin OUT
*.ipin A
*.ipin B
x1 VDD A net1 B VSS nor_custom
x2 VDD OUT net1 VSS inv
.ends

* expanding   symbol:  /foss/designs/PhaseInterpolator/Custom_std_cells/or_x3_custom.sym # of pins=6
** sym_path: /foss/designs/PhaseInterpolator/Custom_std_cells/or_x3_custom.sym
** sch_path: /foss/designs/PhaseInterpolator/Custom_std_cells/or_x3_custom.sch
.subckt or_x3_custom VDD A OUT B C VSS
*.iopin VDD
*.iopin VSS
*.opin OUT
*.ipin A
*.ipin B
*.ipin C
x1 VDD A B C net1 VSS nor_x3_custom
x2 VDD OUT net1 VSS inv
.ends

* expanding   symbol:  /foss/designs/PhaseInterpolator/Custom_std_cells/nand_custom.sym # of pins=5
** sym_path: /foss/designs/PhaseInterpolator/Custom_std_cells/nand_custom.sym
** sch_path: /foss/designs/PhaseInterpolator/Custom_std_cells/nand_custom.sch
.subckt nand_custom VDD OUT A B VSS
*.iopin VDD
*.iopin VSS
*.ipin A
*.ipin B
*.opin OUT
XM1 OUT A net1 VSS sg13_lv_nmos w=0.15u l=0.13u ng=1 m=1
XM2 OUT A VDD VDD sg13_lv_pmos w=0.15u l=0.13u ng=1 m=1
XM3 net1 B VSS VSS sg13_lv_nmos w=0.15u l=0.13u ng=1 m=1
XM4 OUT B VDD VDD sg13_lv_pmos w=0.15u l=0.13u ng=1 m=1
.ends

* expanding   symbol:  /foss/designs/PhaseInterpolator/Custom_std_cells/nand_x3_custom.sym # of pins=6
** sym_path: /foss/designs/PhaseInterpolator/Custom_std_cells/nand_x3_custom.sym
** sch_path: /foss/designs/PhaseInterpolator/Custom_std_cells/nand_x3_custom.sch
.subckt nand_x3_custom VDD OUT A B C VSS
*.ipin A
*.ipin B
*.ipin C
*.iopin VSS
*.iopin VDD
*.opin OUT
XM2 OUT A VDD VDD sg13_lv_pmos w=0.15u l=0.13u ng=1 m=1
XM1 OUT B VDD VDD sg13_lv_pmos w=0.15u l=0.13u ng=1 m=1
XM3 OUT C VDD VDD sg13_lv_pmos w=0.15u l=0.13u ng=1 m=1
XM4 OUT A net1 VSS sg13_lv_nmos w=0.15u l=0.13u ng=1 m=1
XM5 net1 B net2 VSS sg13_lv_nmos w=0.15u l=0.13u ng=1 m=1
XM6 net2 C VSS VSS sg13_lv_nmos w=0.15u l=0.13u ng=1 m=1
.ends

* expanding   symbol:  /foss/designs/PhaseInterpolator/Custom_std_cells/nor_custom.sym # of pins=5
** sym_path: /foss/designs/PhaseInterpolator/Custom_std_cells/nor_custom.sym
** sch_path: /foss/designs/PhaseInterpolator/Custom_std_cells/nor_custom.sch
.subckt nor_custom VDD A OUT B VSS
*.iopin VDD
*.iopin VSS
*.ipin A
*.ipin B
*.opin OUT
XM1 OUT B VSS VSS sg13_lv_nmos w=0.15u l=0.13u ng=1 m=1
XM2 OUT B net1 VDD sg13_lv_pmos w=0.45u l=0.13u ng=1 m=1
XM3 OUT A VSS VSS sg13_lv_nmos w=0.15u l=0.13u ng=1 m=1
XM4 net1 A VDD VDD sg13_lv_pmos w=0.45u l=0.13u ng=1 m=1
.ends

* expanding   symbol:  /foss/designs/PhaseInterpolator/Custom_std_cells/nor_x3_custom.sym # of pins=6
** sym_path: /foss/designs/PhaseInterpolator/Custom_std_cells/nor_x3_custom.sym
** sch_path: /foss/designs/PhaseInterpolator/Custom_std_cells/nor_x3_custom.sch
.subckt nor_x3_custom VDD A B C OUT VSS
*.iopin VDD
*.iopin VSS
*.ipin B
*.ipin C
*.opin OUT
*.ipin A
XM1 OUT A VSS VSS sg13_lv_nmos w=0.15u l=0.13u ng=1 m=1
XM2 OUT C net1 VDD sg13_lv_pmos w=0.45u l=0.13u ng=1 m=1
XM3 OUT B VSS VSS sg13_lv_nmos w=0.15u l=0.13u ng=1 m=1
XM4 net1 B net2 VDD sg13_lv_pmos w=0.45u l=0.13u ng=1 m=1
XM5 net2 A VDD VDD sg13_lv_pmos w=0.45u l=0.13u ng=1 m=1
XM6 OUT C VSS VSS sg13_lv_nmos w=0.15u l=0.13u ng=1 m=1
.ends

.GLOBAL GND
.end
