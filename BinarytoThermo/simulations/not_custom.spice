** sch_path: /foss/designs/PhaseInterpolator/Custom_std_cells/not_custom.sch
**.subckt not_custom VDD A OUT VSS
*.iopin VDD
*.iopin VSS
*.ipin A
*.opin OUT
XM4 OUT A VDD VDD sg13_lv_pmos w=0.45u l=0.13u ng=1 m=1
XM1 OUT A VSS VSS sg13_lv_nmos w=0.15u l=0.13u ng=1 m=1
**.ends
.end
