** sch_path: /foss/designs/PhaseInterpolator/BinarytoThermo/3to7_deco.sch
**.subckt 3to7_deco ST[7],ST[6],ST[5],ST[4],ST[3],ST[2],ST[1] S[2],S[1],S[0] VDD VSS
*.iopin VDD
*.iopin VSS
*.opin ST[7],ST[6],ST[5],ST[4],ST[3],ST[2],ST[1]
*.ipin S[2],S[1],S[0]
x1 VDD ST[2] S[0] S[1] VSS and_custom
x2 VDD S[0] ST[1] S[1] S[2] VSS and_x3_custom
x3 VDD net1 ST[3] net2 VSS or_custom
x4 VDD net1 S[0] S[1] VSS and_custom
x5 VDD net2 S[0] S[2] VSS and_custom
x6 VDD net3 ST[5] S[0] VSS or_custom
x7 VDD net3 S[1] S[2] VSS and_custom
x8 VDD S[0] ST[6] S[1] VSS or_custom
x9 VDD S[0] ST[7] S[1] S[2] VSS or_x3_custom
x10 VDD net4 S[0] VSS inv
x11 VDD ST[4] net4 VSS inv
**.ends

* expanding   symbol:  /foss/designs/PhaseInterpolator/Custom_std_cells/and_custom.sym # of pins=5
** sym_path: /foss/designs/PhaseInterpolator/Custom_std_cells/and_custom.sym
** sch_path: /foss/designs/PhaseInterpolator/Custom_std_cells/and_custom.sch
.subckt and_custom VDD OUT A B VSS
*.ipin A
*.iopin VDD
*.opin OUT
*.iopin VSS
*.ipin B
x1 VDD OUT net1 VSS inv
x2 VDD net1 A B VSS nand_custom
.ends

* expanding   symbol:  /foss/designs/PhaseInterpolator/Custom_std_cells/and_x3_custom.sym # of pins=6
** sym_path: /foss/designs/PhaseInterpolator/Custom_std_cells/and_x3_custom.sym
** sch_path: /foss/designs/PhaseInterpolator/Custom_std_cells/and_x3_custom.sch
.subckt and_x3_custom VDD A OUT B C VSS
*.iopin VDD
*.iopin VSS
*.ipin A
*.ipin B
*.ipin C
*.opin OUT
x1 VDD net1 A B C VSS nand_x3_custom
x2 VDD OUT net1 VSS inv
.ends

* expanding   symbol:  /foss/designs/PhaseInterpolator/Custom_std_cells/or_custom.sym # of pins=5
** sym_path: /foss/designs/PhaseInterpolator/Custom_std_cells/or_custom.sym
** sch_path: /foss/designs/PhaseInterpolator/Custom_std_cells/or_custom.sch
.subckt or_custom VDD A OUT B VSS
*.iopin VDD
*.iopin VSS
*.opin OUT
*.ipin A
*.ipin B
x1 VDD A net1 B VSS nor_custom
x2 VDD OUT net1 VSS inv
.ends

* expanding   symbol:  /foss/designs/PhaseInterpolator/Custom_std_cells/or_x3_custom.sym # of pins=6
** sym_path: /foss/designs/PhaseInterpolator/Custom_std_cells/or_x3_custom.sym
** sch_path: /foss/designs/PhaseInterpolator/Custom_std_cells/or_x3_custom.sch
.subckt or_x3_custom VDD A OUT B C VSS
*.iopin VDD
*.iopin VSS
*.opin OUT
*.ipin A
*.ipin B
*.ipin C
x1 VDD A B C net1 VSS nor_x3_custom
x2 VDD OUT net1 VSS inv
.ends

* expanding   symbol:  /foss/designs/PhaseInterpolator/Custom_std_cells/inv.sym # of pins=4
** sym_path: /foss/designs/PhaseInterpolator/Custom_std_cells/inv.sym
** sch_path: /foss/designs/PhaseInterpolator/Custom_std_cells/inv.sch
.subckt inv VDD VOUT VIN VSS
*.iopin VDD
*.iopin VSS
*.opin VOUT
*.ipin VIN
XM2 VOUT VIN VDD VDD sg13_lv_pmos w=0.15u l=0.13u ng=1 m=2
XM1 VOUT VIN VSS VSS sg13_lv_nmos w=0.15u l=0.13u ng=1 m=1
.ends

* expanding   symbol:  /foss/designs/PhaseInterpolator/Custom_std_cells/nand_custom.sym # of pins=5
** sym_path: /foss/designs/PhaseInterpolator/Custom_std_cells/nand_custom.sym
** sch_path: /foss/designs/PhaseInterpolator/Custom_std_cells/nand_custom.sch
.subckt nand_custom VDD OUT A B VSS
*.iopin VDD
*.iopin VSS
*.ipin A
*.ipin B
*.opin OUT
XM1 OUT A net1 VSS sg13_lv_nmos w=0.15u l=0.13u ng=1 m=1
XM2 OUT A VDD VDD sg13_lv_pmos w=0.15u l=0.13u ng=1 m=1
XM3 net1 B VSS VSS sg13_lv_nmos w=0.15u l=0.13u ng=1 m=1
XM4 OUT B VDD VDD sg13_lv_pmos w=0.15u l=0.13u ng=1 m=1
.ends

* expanding   symbol:  /foss/designs/PhaseInterpolator/Custom_std_cells/nand_x3_custom.sym # of pins=6
** sym_path: /foss/designs/PhaseInterpolator/Custom_std_cells/nand_x3_custom.sym
** sch_path: /foss/designs/PhaseInterpolator/Custom_std_cells/nand_x3_custom.sch
.subckt nand_x3_custom VDD OUT A B C VSS
*.ipin A
*.ipin B
*.ipin C
*.iopin VSS
*.iopin VDD
*.opin OUT
XM2 OUT A VDD VDD sg13_lv_pmos w=0.15u l=0.13u ng=1 m=1
XM1 OUT B VDD VDD sg13_lv_pmos w=0.15u l=0.13u ng=1 m=1
XM3 OUT C VDD VDD sg13_lv_pmos w=0.15u l=0.13u ng=1 m=1
XM4 OUT A net1 VSS sg13_lv_nmos w=0.15u l=0.13u ng=1 m=1
XM5 net1 B net2 VSS sg13_lv_nmos w=0.15u l=0.13u ng=1 m=1
XM6 net2 C VSS VSS sg13_lv_nmos w=0.15u l=0.13u ng=1 m=1
.ends

* expanding   symbol:  /foss/designs/PhaseInterpolator/Custom_std_cells/nor_custom.sym # of pins=5
** sym_path: /foss/designs/PhaseInterpolator/Custom_std_cells/nor_custom.sym
** sch_path: /foss/designs/PhaseInterpolator/Custom_std_cells/nor_custom.sch
.subckt nor_custom VDD A OUT B VSS
*.iopin VDD
*.iopin VSS
*.ipin A
*.ipin B
*.opin OUT
XM1 OUT B VSS VSS sg13_lv_nmos w=0.15u l=0.13u ng=1 m=1
XM2 OUT B net1 VDD sg13_lv_pmos w=0.45u l=0.13u ng=1 m=1
XM3 OUT A VSS VSS sg13_lv_nmos w=0.15u l=0.13u ng=1 m=1
XM4 net1 A VDD VDD sg13_lv_pmos w=0.45u l=0.13u ng=1 m=1
.ends

* expanding   symbol:  /foss/designs/PhaseInterpolator/Custom_std_cells/nor_x3_custom.sym # of pins=6
** sym_path: /foss/designs/PhaseInterpolator/Custom_std_cells/nor_x3_custom.sym
** sch_path: /foss/designs/PhaseInterpolator/Custom_std_cells/nor_x3_custom.sch
.subckt nor_x3_custom VDD A B C OUT VSS
*.iopin VDD
*.iopin VSS
*.ipin B
*.ipin C
*.opin OUT
*.ipin A
XM1 OUT A VSS VSS sg13_lv_nmos w=0.15u l=0.13u ng=1 m=1
XM2 OUT C net1 VDD sg13_lv_pmos w=0.45u l=0.13u ng=1 m=1
XM3 OUT B VSS VSS sg13_lv_nmos w=0.15u l=0.13u ng=1 m=1
XM4 net1 B net2 VDD sg13_lv_pmos w=0.45u l=0.13u ng=1 m=1
XM5 net2 A VDD VDD sg13_lv_pmos w=0.45u l=0.13u ng=1 m=1
XM6 OUT C VSS VSS sg13_lv_nmos w=0.15u l=0.13u ng=1 m=1
.ends

.end
