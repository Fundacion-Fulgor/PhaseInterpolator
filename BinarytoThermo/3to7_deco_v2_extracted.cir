* Extracted by KLayout with SG13G2 LVS runset on : 03/03/2026 18:31

.SUBCKT 3to7_deco_v2 VSS ST[1] ST[2] ST[3] ST[4] ST[5] ST[6] ST[7] VDD S[2]
+ S[1] S[0]
X$1 VSS \$12 \$11 VDD \$10 and_custom
X$2 VSS VDD \$11 \$12 \$14 or_custom
X$3 \$12 \$13 VDD VSS \$11 ST[7] nand_x3_custom
X$4 \$13 \$14 VDD VSS ST[5] nand_custom
X$5 \$13 \$12 VDD VSS ST[6] nand_custom
X$6 VDD \$13 VSS ST[4] inv
X$7 VDD S[2] VSS \$13 inv
X$8 VDD S[1] VSS \$12 inv
X$9 VDD S[0] VSS \$11 inv
X$10 VDD VSS \$13 \$10 ST[3] nor_custom
X$11 VDD VSS \$13 \$12 ST[2] nor_custom
X$12 VDD VSS \$13 \$12 \$11 ST[1] nor_x3_custom
.ENDS 3to7_deco_v2

.SUBCKT nand_x3_custom B C VDD VSS A OUT
M$1 OUT A \$7 VSS sg13_lv_nmos L=0.13u W=0.15u AS=0.1005p AD=0.0555p PS=1.34u
+ PD=0.74u
M$2 \$7 B \$8 VSS sg13_lv_nmos L=0.13u W=0.15u AS=0.0555p AD=0.0555p PS=0.74u
+ PD=0.74u
M$3 \$8 C VSS VSS sg13_lv_nmos L=0.13u W=0.15u AS=0.0555p AD=0.1005p PS=0.74u
+ PD=1.34u
M$4 VDD A OUT VDD sg13_lv_pmos L=0.13u W=0.15u AS=0.1005p AD=0.0555p PS=1.34u
+ PD=0.74u
M$5 OUT B VDD VDD sg13_lv_pmos L=0.13u W=0.15u AS=0.0555p AD=0.0555p PS=0.74u
+ PD=0.74u
M$6 VDD C OUT VDD sg13_lv_pmos L=0.13u W=0.15u AS=0.0555p AD=0.1005p PS=0.74u
+ PD=1.34u
.ENDS nand_x3_custom

.SUBCKT or_custom VSS VDD A B OUT
X$1 VDD VSS B A \$2 nor_custom
X$2 VDD \$2 VSS OUT inv
.ENDS or_custom

.SUBCKT and_custom VSS A B VDD OUT
X$1 B A VDD VSS \$1 nand_custom
X$2 VDD \$1 VSS OUT inv
.ENDS and_custom

.SUBCKT nor_x3_custom VDD VSS C B A OUT
M$1 VSS A OUT VSS sg13_lv_nmos L=0.13u W=0.15u AS=0.1005p AD=0.0555p PS=1.34u
+ PD=0.74u
M$2 OUT B VSS VSS sg13_lv_nmos L=0.13u W=0.15u AS=0.0555p AD=0.0555p PS=0.74u
+ PD=0.74u
M$3 VSS C OUT VSS sg13_lv_nmos L=0.13u W=0.15u AS=0.0555p AD=0.1005p PS=0.74u
+ PD=1.34u
M$4 VDD A \$7 VDD sg13_lv_pmos L=0.13u W=0.15u AS=0.1005p AD=0.0555p PS=1.34u
+ PD=0.74u
M$5 \$7 B \$8 VDD sg13_lv_pmos L=0.13u W=0.15u AS=0.0555p AD=0.0555p PS=0.74u
+ PD=0.74u
M$6 \$8 C OUT VDD sg13_lv_pmos L=0.13u W=0.15u AS=0.0555p AD=0.1005p PS=0.74u
+ PD=1.34u
.ENDS nor_x3_custom

.SUBCKT nand_custom B A VDD VSS OUT
M$1 OUT A \$6 VSS sg13_lv_nmos L=0.13u W=0.15u AS=0.1005p AD=0.0555p PS=1.34u
+ PD=0.74u
M$2 \$6 B VSS VSS sg13_lv_nmos L=0.13u W=0.15u AS=0.0555p AD=0.1005p PS=0.74u
+ PD=1.34u
M$3 VDD A OUT VDD sg13_lv_pmos L=0.13u W=0.15u AS=0.1005p AD=0.0555p PS=1.34u
+ PD=0.74u
M$4 OUT B VDD VDD sg13_lv_pmos L=0.13u W=0.15u AS=0.0555p AD=0.1005p PS=0.74u
+ PD=1.34u
.ENDS nand_custom

.SUBCKT nor_custom VDD VSS B A OUT
M$1 VSS A OUT VSS sg13_lv_nmos L=0.13u W=0.15u AS=0.1005p AD=0.0555p PS=1.34u
+ PD=0.74u
M$2 OUT B VSS VSS sg13_lv_nmos L=0.13u W=0.15u AS=0.0555p AD=0.1005p PS=0.74u
+ PD=1.34u
M$3 VDD A \$6 VDD sg13_lv_pmos L=0.13u W=0.15u AS=0.1005p AD=0.0555p PS=1.34u
+ PD=0.74u
M$4 \$6 B OUT VDD sg13_lv_pmos L=0.13u W=0.15u AS=0.0555p AD=0.1005p PS=0.74u
+ PD=1.34u
.ENDS nor_custom

.SUBCKT inv VDD VIN VSS VOUT
M$1 VSS VIN VOUT VSS sg13_lv_nmos L=0.13u W=0.15u AS=0.1005p AD=0.1005p
+ PS=1.34u PD=1.34u
M$2 VDD VIN VOUT VDD sg13_lv_pmos L=0.13u W=0.15u AS=0.1005p AD=0.1005p
+ PS=1.34u PD=1.34u
.ENDS inv
