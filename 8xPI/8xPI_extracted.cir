* Extracted by KLayout with SG13G2 LVS runset on : 04/03/2026 01:00

.SUBCKT 8xPI VSS VINQB VS[1] VINQ VINIB VST[7] VS[0] VINI VDD VST[6] VST[5]
+ VST[4] VOUT VST[3] VST[2] VST[1] VST[0]
X$1 VST[7] VSS VDD VINI VINIB VINQ VINQB VS[0] VS[1] \$6 MUX_4_1
X$2 VST[4] VSS VDD VINI VINIB VINQ VINQB VS[0] VS[1] \$6 MUX_4_1
X$3 VST[6] VSS VDD VINI VINIB VINQ VINQB VS[0] VS[1] \$6 MUX_4_1
X$4 VST[0] VSS VDD VINI VINIB VINQ VINQB VS[0] VS[1] \$6 MUX_4_1
X$5 VST[1] VSS VDD VINI VINIB VINQ VINQB VS[0] VS[1] \$6 MUX_4_1
X$6 VST[2] VSS VDD VINI VINIB VINQ VINQB VS[0] VS[1] \$6 MUX_4_1
X$7 VST[3] VSS VDD VINI VINIB VINQ VINQB VS[0] VS[1] \$6 MUX_4_1
X$8 VST[5] VSS VDD VINI VINIB VINQ VINQB VS[0] VS[1] \$6 MUX_4_1
X$9 VSS \$6 \$33 VDD inv_PI
X$10 VSS VDD \$33 VOUT buff_PI_d16
.ENDS 8xPI

.SUBCKT buff_PI_d16 VSS VDD VIN VOUT
X$1 \$9 \$13 VSS VDD inv_PI_d8
X$2 VSS VDD \$13 VOUT inv_PI_d16
X$3 \$6 \$9 VSS VDD inv_PI_d4
X$4 VSS VIN \$6 VDD inv_PI_d2
.ENDS buff_PI_d16

.SUBCKT MUX_4_1 VST VSS VDD VINA VINB VINC VIND VS[0] VS[1] VOUT
X$1 VSS VINB \$1 VS[0] VDD VINA MUX_2_1
X$2 VSS \$2 VOUT VST VDD \$1 MUX_2_1
X$3 VSS VIND \$2 VS[1] VDD VINC MUX_2_1
.ENDS MUX_4_1

.SUBCKT inv_PI_d16 VSS VDD VIN VOUT
X$1 VIN VOUT VSS VDD inv_PI_d8
X$2 VIN VOUT VSS VDD inv_PI_d8
.ENDS inv_PI_d16

.SUBCKT MUX_2_1 VSS VINB VOUT VS VDD VINA
X$1 VSS \$6 \$9 \$12 \$11 VDD tg_custom
X$2 VSS \$6 \$9 \$12 \$11 VDD tg_custom
X$3 VSS \$9 VDD tiel_custom
X$4 VSS \$6 \$9 \$12 \$11 VDD tg_custom
X$5 VSS \$6 \$9 \$12 \$11 VDD tg_custom
X$6 VSS \$6 \$9 \$12 \$11 VDD tg_custom
X$7 VSS VOUT \$11 \$6 \$9 VDD tg_custom
X$8 VSS \$6 \$9 \$12 \$11 VDD tg_custom
X$9 VSS VINB \$12 VDD inv_PI
X$10 VSS \$6 VS \$12 \$10 VDD tg_custom
X$11 VSS \$13 \$9 \$22 \$11 VDD tg_custom
X$12 VSS \$13 \$9 \$22 \$11 VDD tg_custom
X$13 VSS VOUT \$11 \$13 \$9 VDD tg_custom
X$14 VSS \$13 \$9 \$22 \$11 VDD tg_custom
X$15 VSS \$13 \$9 \$22 \$11 VDD tg_custom
X$16 VSS \$13 \$9 \$22 \$11 VDD tg_custom
X$17 VSS \$13 \$9 \$22 \$11 VDD tg_custom
X$18 VSS VDD \$11 tieh_custom
X$19 VSS \$13 \$10 \$22 VS VDD tg_custom
X$20 VSS VINA \$22 VDD inv_PI
X$21 VDD VS VSS \$10 inv
.ENDS MUX_2_1

.SUBCKT inv_PI_d8 VIN VOUT VSS VDD
X$1 VIN VOUT VSS VDD inv_PI_d4
X$2 VIN VOUT VSS VDD inv_PI_d4
.ENDS inv_PI_d8

.SUBCKT tieh_custom VSS VDD VOUT
M$1 VSS \$2 \$2 VSS sg13_lv_nmos L=0.13u W=0.15u AS=0.1005p AD=0.1005p PS=1.34u
+ PD=1.34u
M$2 VDD \$2 VOUT VDD sg13_lv_pmos L=0.13u W=0.15u AS=0.1005p AD=0.1005p
+ PS=1.34u PD=1.34u
.ENDS tieh_custom

.SUBCKT tiel_custom VSS VOUT VDD
M$1 VSS \$2 VOUT VSS sg13_lv_nmos L=0.13u W=0.15u AS=0.1005p AD=0.1005p
+ PS=1.34u PD=1.34u
M$2 VDD \$2 \$2 VDD sg13_lv_pmos L=0.13u W=0.15u AS=0.1005p AD=0.1005p PS=1.34u
+ PD=1.34u
.ENDS tiel_custom

.SUBCKT tg_custom VBN VOUT VSN VIN VSP VBP
M$1 VIN VSN VOUT VBN sg13_lv_nmos L=0.13u W=0.15u AS=0.1005p AD=0.1005p
+ PS=1.34u PD=1.34u
M$2 VIN VSP VOUT VBP sg13_lv_pmos L=0.13u W=0.3u AS=0.156p AD=0.156p PS=2.08u
+ PD=2.08u
.ENDS tg_custom

.SUBCKT inv VDD VIN VSS VOUT
M$1 VSS VIN VOUT VSS sg13_lv_nmos L=0.13u W=0.15u AS=0.1005p AD=0.1005p
+ PS=1.34u PD=1.34u
M$2 VDD VIN VOUT VDD sg13_lv_pmos L=0.13u W=0.15u AS=0.1005p AD=0.1005p
+ PS=1.34u PD=1.34u
.ENDS inv

.SUBCKT inv_PI_d4 VIN VOUT VSS VDD
X$1 VSS VIN VOUT VDD inv_PI_d2
X$2 VSS VIN VOUT VDD inv_PI_d2
.ENDS inv_PI_d4

.SUBCKT inv_PI_d2 VSS VIN VOUT VDD
X$1 VSS VIN VOUT VDD inv_PI
X$2 VSS VIN VOUT VDD inv_PI
.ENDS inv_PI_d2

.SUBCKT inv_PI VSS VIN VOUT VDD
M$1 VSS VIN VOUT VSS sg13_lv_nmos L=0.13u W=0.3u AS=0.156p AD=0.156p PS=2.08u
+ PD=2.08u
M$3 VDD VIN VOUT VDD sg13_lv_pmos L=0.13u W=0.45u AS=0.2115p AD=0.2115p
+ PS=2.82u PD=2.82u
.ENDS inv_PI
