** sch_path: /foss/designs/PhaseInterpolator/Clock_Gen/clock_gen.sch
**.subckt clock_gen PH0 PH90 VDD CTRL PH180 VSS PH270
*.iopin VDD
*.iopin VSS
*.ipin CTRL
*.opin PH0
*.opin PH90
*.opin PH180
*.opin PH270
x1 CTRL v0 v3 v2 v5 v4 v1 VSS VDD 6ph_rosc
x16 VDD v4 v270 v5 VSS PI_clk
x2 VDD v1 v90 v2 VSS PI_clk
x8 VDD net9 v0 VSS inv_PI_d2
x9 VDD net10 v3 VSS inv_PI_d2
x10 VDD v360 net9 VSS inv_PI_d2
x11 VDD v180 net10 VSS inv_PI_d2
x3 VDD net6 v180 VSS buff_PI_d16
x4 VDD net7 v90 VSS buff_PI_d16
x5 VDD net5 v360 VSS buff_PI_d16
x6 VDD net8 v270 VSS buff_PI_d16
x7 VDD v180 v360 VSS flywheel_clk
x12 VDD v270 v90 VSS flywheel_clk
x13 VDD net2 net6 VSS inv_PI_d16
x14 VDD net3 net7 VSS inv_PI_d16
x15 VDD net4 net5 VSS inv_PI_d16
x17 VDD net1 net8 VSS inv_PI_d16
x18 VDD PH180 net2 VSS inv_PI_d32
x19 VDD PH90 net3 VSS inv_PI_d32
x20 VDD PH0 net4 VSS inv_PI_d32
x21 VDD PH270 net1 VSS inv_PI_d32
**.ends

* expanding   symbol:  6ph_rosc.sym # of pins=9
** sym_path: /foss/designs/PhaseInterpolator/Clock_Gen/6ph_rosc.sym
** sch_path: /foss/designs/PhaseInterpolator/Clock_Gen/6ph_rosc.sch
.subckt 6ph_rosc CTRL Ph0 Ph3 Ph2 Ph5 Ph4 Ph1 VSS VDD
*.iopin VDD
*.iopin VSS
*.ipin CTRL
*.opin Ph0
*.opin Ph2
*.opin Ph5
*.opin Ph1
*.opin Ph4
*.opin Ph3
x1 VDD net1 net2 CTRL net6 net5 VSS psdiff
x2 VDD net3 net4 CTRL net2 net1 VSS psdiff
x3 VDD net5 net6 CTRL net4 net3 VSS psdiff
x4 CTRL Ph0 Ph3 VDD decap
x5 CTRL Ph2 Ph5 VDD decap
x6 CTRL Ph1 Ph4 VDD decap
x7 VDD Ph1 net2 VSS buff_d8
x8 VDD Ph4 net1 VSS buff_d8
x9 VDD Ph5 net4 VSS buff_d8
x10 VDD Ph2 net3 VSS buff_d8
x11 VDD Ph3 net6 VSS buff_d8
x12 VDD Ph0 net5 VSS buff_d8
x19 VDD Ph2 Ph5 VSS flywheel
x17 VDD Ph0 Ph3 VSS flywheel
x13 VDD Ph4 Ph1 VSS flywheel
.ends

* expanding   symbol:  PI_clk.sym # of pins=5
** sym_path: /foss/designs/PhaseInterpolator/Clock_Gen/PI_clk.sym
** sch_path: /foss/designs/PhaseInterpolator/Clock_Gen/PI_clk.sch
.subckt PI_clk VDD PH0 PHOUT PH1 VSS
*.iopin VDD
*.iopin VSS
*.ipin PH0
*.ipin PH1
*.opin PHOUT
x5 VDD net1 PH0 VSS inv_PI_d2
x6 VDD net1 PH1 VSS inv_PI_d2
x7 VDD PHOUT net1 VSS inv_PI_d2
.ends

* expanding   symbol:  /foss/designs/PhaseInterpolator/Custom_std_cells/inv_PI_d2.sym # of pins=4
** sym_path: /foss/designs/PhaseInterpolator/Custom_std_cells/inv_PI_d2.sym
** sch_path: /foss/designs/PhaseInterpolator/Custom_std_cells/inv_PI_d2.sch
.subckt inv_PI_d2 VDD VOUT VIN VSS
*.ipin VIN
*.opin VOUT
*.iopin VDD
*.iopin VSS
x1[1] VDD VOUT VIN VSS inv_PI
x1[0] VDD VOUT VIN VSS inv_PI
.ends

* expanding   symbol:  /foss/designs/PhaseInterpolator/Custom_std_cells/buff_PI_d16.sym # of pins=4
** sym_path: /foss/designs/PhaseInterpolator/Custom_std_cells/buff_PI_d16.sym
** sch_path: /foss/designs/PhaseInterpolator/Custom_std_cells/buff_PI_d16.sch
.subckt buff_PI_d16 VDD VOUT VIN VSS
*.ipin VIN
*.opin VOUT
*.iopin VDD
*.iopin VSS
x7 VDD net1 VIN VSS inv_PI_d2
x8 VDD net2 net1 VSS inv_PI_d4
x9 VDD net3 net2 VSS inv_PI_d8
x10 VDD VOUT net3 VSS inv_PI_d16
.ends

* expanding   symbol:  flywheel_clk.sym # of pins=4
** sym_path: /foss/designs/PhaseInterpolator/Clock_Gen/flywheel_clk.sym
** sch_path: /foss/designs/PhaseInterpolator/Clock_Gen/flywheel_clk.sch
.subckt flywheel_clk VDD PH1 PH0 VSS
*.iopin VDD
*.iopin VSS
*.iopin PH1
*.iopin PH0
x13 VDD PH1 PH0 VSS inv_d4
x14 VDD PH0 PH1 VSS inv_d2
.ends

* expanding   symbol:  /foss/designs/PhaseInterpolator/Custom_std_cells/inv_PI_d16.sym # of pins=4
** sym_path: /foss/designs/PhaseInterpolator/Custom_std_cells/inv_PI_d16.sym
** sch_path: /foss/designs/PhaseInterpolator/Custom_std_cells/inv_PI_d16.sch
.subckt inv_PI_d16 VDD VOUT VIN VSS
*.ipin VIN
*.opin VOUT
*.iopin VDD
*.iopin VSS
x1[1] VDD VOUT VIN VSS inv_PI_d8
x1[0] VDD VOUT VIN VSS inv_PI_d8
.ends

* expanding   symbol:  /foss/designs/PhaseInterpolator/Custom_std_cells/inv_PI_d32.sym # of pins=4
** sym_path: /foss/designs/PhaseInterpolator/Custom_std_cells/inv_PI_d32.sym
** sch_path: /foss/designs/PhaseInterpolator/Custom_std_cells/inv_PI_d32.sch
.subckt inv_PI_d32 VDD VOUT VIN VSS
*.ipin VIN
*.opin VOUT
*.iopin VDD
*.iopin VSS
x1[1] VDD VOUT VIN VSS inv_PI_d16
x1[0] VDD VOUT VIN VSS inv_PI_d16
.ends

* expanding   symbol:  psdiff.sym # of pins=7
** sym_path: /foss/designs/PhaseInterpolator/Clock_Gen/psdiff.sym
** sch_path: /foss/designs/PhaseInterpolator/Clock_Gen/psdiff.sch
.subckt psdiff VDD VOUTDN VOUTDP CTRL CLKN CLKP VSS
*.iopin VSS
*.ipin CLKP
*.ipin CLKN
*.iopin VDD
*.ipin CTRL
*.opin VOUTDN
*.opin VOUTDP
XM1 net1 CLKP VSS VSS sg13_lv_nmos w=1.5u l=0.13u ng=10 m=3
XM2 net2 CLKN VSS VSS sg13_lv_nmos w=1.5u l=0.13u ng=10 m=3
XM3 net3 CTRL net1 VSS sg13_lv_nmos w=0.3u l=0.13u ng=2 m=1
XM4 net4 CTRL net2 VSS sg13_lv_nmos w=0.3u l=0.13u ng=2 m=1
XM6 net2 net3 VDD VDD sg13_lv_pmos w=1.5u l=0.13u ng=10 m=1
XM5 net1 net4 VDD VDD sg13_lv_pmos w=1.5u l=0.13u ng=10 m=1
XM7 net1 VSS VDD VDD sg13_lv_pmos w=1.5u l=0.13u ng=10 m=2
XM8 net2 VSS VDD VDD sg13_lv_pmos w=1.5u l=0.13u ng=10 m=2
x1 VDD VOUTDP net2 VSS buff_d8
x2 VDD VOUTDN net1 VSS buff_d8
.ends

* expanding   symbol:  decap.sym # of pins=4
** sym_path: /foss/designs/PhaseInterpolator/Clock_Gen/decap.sym
** sch_path: /foss/designs/PhaseInterpolator/Clock_Gen/decap.sch
.subckt decap CTRL VOUTDN VOUTDP VDD
*.ipin CTRL
*.ipin VDD
*.ipin VOUTDN
*.ipin VOUTDP
XM10 CTRL VOUTDP CTRL VDD sg13_lv_pmos w=8u l=0.13u ng=8 m=4
XM9 CTRL VOUTDN CTRL VDD sg13_lv_pmos w=8u l=0.13u ng=8 m=4
.ends

* expanding   symbol:  /foss/designs/PhaseInterpolator/Custom_std_cells/buff_d8.sym # of pins=4
** sym_path: /foss/designs/PhaseInterpolator/Custom_std_cells/buff_d8.sym
** sch_path: /foss/designs/PhaseInterpolator/Custom_std_cells/buff_d8.sch
.subckt buff_d8 VDD VOUT VIN VSS
*.ipin VIN
*.opin VOUT
*.iopin VDD
*.iopin VSS
x7 VDD net1 VIN VSS inv
x8 VDD net2 net1 VSS inv_d2
x9 VDD net3 net2 VSS inv_d4
x10 VDD VOUT net3 VSS inv_d8
.ends

* expanding   symbol:  flywheel.sym # of pins=4
** sym_path: /foss/designs/PhaseInterpolator/Clock_Gen/flywheel.sym
** sch_path: /foss/designs/PhaseInterpolator/Clock_Gen/flywheel.sch
.subckt flywheel VDD PH1 PH0 VSS
*.iopin VDD
*.iopin VSS
*.iopin PH1
*.iopin PH0
x13 VDD PH1 PH0 VSS inv_d2
x14 VDD PH0 PH1 VSS inv_d2
.ends

* expanding   symbol:  /foss/designs/PhaseInterpolator/Custom_std_cells/inv_PI.sym # of pins=4
** sym_path: /foss/designs/PhaseInterpolator/Custom_std_cells/inv_PI.sym
** sch_path: /foss/designs/PhaseInterpolator/Custom_std_cells/inv_PI.sch
.subckt inv_PI VDD VOUT VIN VSS
*.iopin VDD
*.iopin VSS
*.opin VOUT
*.ipin VIN
XM2 VOUT VIN VDD VDD sg13_lv_pmos w=0.45u l=0.13u ng=3 m=1
XM1 VOUT VIN VSS VSS sg13_lv_nmos w=0.3u l=0.13u ng=2 m=1
.ends

* expanding   symbol:  /foss/designs/PhaseInterpolator/Custom_std_cells/inv_PI_d4.sym # of pins=4
** sym_path: /foss/designs/PhaseInterpolator/Custom_std_cells/inv_PI_d4.sym
** sch_path: /foss/designs/PhaseInterpolator/Custom_std_cells/inv_PI_d4.sch
.subckt inv_PI_d4 VDD VOUT VIN VSS
*.ipin VIN
*.opin VOUT
*.iopin VDD
*.iopin VSS
x1[1] VDD VOUT VIN VSS inv_PI_d2
x1[0] VDD VOUT VIN VSS inv_PI_d2
.ends

* expanding   symbol:  /foss/designs/PhaseInterpolator/Custom_std_cells/inv_PI_d8.sym # of pins=4
** sym_path: /foss/designs/PhaseInterpolator/Custom_std_cells/inv_PI_d8.sym
** sch_path: /foss/designs/PhaseInterpolator/Custom_std_cells/inv_PI_d8.sch
.subckt inv_PI_d8 VDD VOUT VIN VSS
*.ipin VIN
*.opin VOUT
*.iopin VDD
*.iopin VSS
x1[1] VDD VOUT VIN VSS inv_PI_d4
x1[0] VDD VOUT VIN VSS inv_PI_d4
.ends

* expanding   symbol:  /foss/designs/PhaseInterpolator/Custom_std_cells/inv_d4.sym # of pins=4
** sym_path: /foss/designs/PhaseInterpolator/Custom_std_cells/inv_d4.sym
** sch_path: /foss/designs/PhaseInterpolator/Custom_std_cells/inv_d4.sch
.subckt inv_d4 VDD VOUT VIN VSS
*.ipin VIN
*.opin VOUT
*.iopin VDD
*.iopin VSS
x1[1] VDD VOUT VIN VSS inv_d2
x1[0] VDD VOUT VIN VSS inv_d2
.ends

* expanding   symbol:  /foss/designs/PhaseInterpolator/Custom_std_cells/inv_d2.sym # of pins=4
** sym_path: /foss/designs/PhaseInterpolator/Custom_std_cells/inv_d2.sym
** sch_path: /foss/designs/PhaseInterpolator/Custom_std_cells/inv_d2.sch
.subckt inv_d2 VDD VOUT VIN VSS
*.ipin VIN
*.opin VOUT
*.iopin VDD
*.iopin VSS
x1[1] VDD VOUT VIN VSS inv
x1[0] VDD VOUT VIN VSS inv
.ends

* expanding   symbol:  /foss/designs/PhaseInterpolator/Custom_std_cells/inv.sym # of pins=4
** sym_path: /foss/designs/PhaseInterpolator/Custom_std_cells/inv.sym
** sch_path: /foss/designs/PhaseInterpolator/Custom_std_cells/inv.sch
.subckt inv VDD VOUT VIN VSS
*.iopin VDD
*.iopin VSS
*.opin VOUT
*.ipin VIN
XM2 VOUT VIN VDD VDD sg13_lv_pmos w=0.15u l=0.13u ng=1 m=1
XM1 VOUT VIN VSS VSS sg13_lv_nmos w=0.15u l=0.13u ng=1 m=1
.ends

* expanding   symbol:  /foss/designs/PhaseInterpolator/Custom_std_cells/inv_d8.sym # of pins=4
** sym_path: /foss/designs/PhaseInterpolator/Custom_std_cells/inv_d8.sym
** sch_path: /foss/designs/PhaseInterpolator/Custom_std_cells/inv_d8.sch
.subckt inv_d8 VDD VOUT VIN VSS
*.ipin VIN
*.opin VOUT
*.iopin VDD
*.iopin VSS
x1[1] VDD VOUT VIN VSS inv_d4
x1[0] VDD VOUT VIN VSS inv_d4
.ends

.end
