** sch_path: /foss/designs/PhaseInterpolator/Clock_Gen/decap.sch
.subckt decap CTRL VOUTDN VOUTDP VDD
*.PININFO CTRL:I VDD:I VOUTDN:I VOUTDP:I
M10 CTRL VOUTDP CTRL VDD sg13_lv_pmos w=8u l=0.13u ng=8 m=4
M9 CTRL VOUTDN CTRL VDD sg13_lv_pmos w=8u l=0.13u ng=8 m=4
.ends
