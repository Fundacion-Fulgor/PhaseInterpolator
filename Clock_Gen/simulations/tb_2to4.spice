** sch_path: /foss/designs/PhaseInterpolator/Clock_Gen/tb_2to4.sch
**.subckt tb_2to4
Vdd1 vdd GND 1.2
Vdd4 vc GND 0.9
x3 v0 v180 v90 v270 vss vss vdd vdd vdd vdd vss vss vss vss pi_vout vdd GND 8xPI
Vdd3 vss GND 0
x1 v0 v90 vdd vc v180 GND v270 clock_gen
x2 vdd pi_vout vout vss div_freq_x8
**** begin user architecture code

.save v(vin1) v(v0) v(v90) v(v270) v(v180) v(vin2) v(vout) v(pi_vout)

.tran 5p 16n
.save all

.control
run
set color0=white
write tran_logic.raw

* --- MEDICIONES DE FASE Y RETARDO (Usando v90) ---
* Periodo Entrada (Ref)
*meas tran T_p90 TRIG v(vin1) VAL=0.6 RISE=3 TARG v(vin1) VAL=0.6 RISE=4

* Retardo (Entrada vs v90)
*meas tran T_d90 TRIG v(vin1) VAL=0.6 RISE=3 TARG v(v90) VAL=0.6 RISE=3

* Calculo Fase
*let Phase_D90= (T_d90 / T_p90) * 360

*print T_p90
*print T_d90
*print Phase_D90

* --- DUTY CYCLE (Usando v90) ---
* Periodo Salida
*meas tran T_pe90 TRIG v(v90) VAL=0.6 RISE=2 TARG v(v90) VAL=0.6 RISE=3

* Tiempo en ALTO (Ton)
* Desde que sube (RISE=2) hasta que baja (FALL=2)
*meas tran T_h90 TRIG v(v90) VAL=0.6 RISE=2 TARG v(v90) VAL=0.6 FALL=2

* Tiempo en BAJO (Toff)
* Desde que baja (FALL=2) hasta que sube de nuevo (RISE=3)
*meas tran T_l90 TRIG v(v90) VAL=0.6 FALL=2 TARG v(v90) VAL=0.6 RISE=3

*let Duty_H90 = (T_h90 / T_pe90) * 100
*let Duty_L90 = (T_l90 / T_pe90) * 100

*print Duty_H90
*print Duty_L90

meas tran SKEW0_90 TRIG v(v0) VAL=0.6 RISE=3 TARG v(v90) VAL=0.6 RISE=4
meas tran SKEW90_180 TRIG v(v90) VAL=0.6 RISE=3 TARG v(v180) VAL=0.6 RISE=4
meas tran SKEW180_270 TRIG v(v180) VAL=0.6 RISE=3 TARG v(v270) VAL=0.6 RISE=3
meas tran SKEW270_0 TRIG v(v270) VAL=0.6 RISE=3 TARG v(v0) VAL=0.6 RISE=3

meas tran T90 TRIG v(v90) VAL=0.6 RISE=3 TARG v(v90) VAL=0.6 RISE=4
meas tran T180 TRIG v(v180) VAL=0.6 RISE=3 TARG v(v180) VAL=0.6 RISE=4
meas tran T270 TRIG v(v270) VAL=0.6 RISE=3 TARG v(v270) VAL=0.6 RISE=4
meas tran T0 TRIG v(v0) VAL=0.6 RISE=3 TARG v(v0) VAL=0.6 RISE=4

let period_0 = T0

let phase0_90 = (SKEW0_90 / period_0) * 360
let phase90_180 = (SKEW90_180 / period_0) * 360
let phase180_270 = (SKEW180_270 / period_0) * 360
let phase270_0 = (SKEW270_0 / period_0) * 360

meas tran PW0 TRIG v(v0) VAL=0.6 RISE=3 TARG v(v0) VAL=0.6 FALL=4
meas tran PW90 TRIG v(v90) VAL=0.6 RISE=3 TARG v(v90) VAL=0.6 FALL=3
meas tran PW180 TRIG v(v180) VAL=0.6 RISE=3 TARG v(v180) VAL=0.6 FALL=4
meas tran PW270 TRIG v(v270) VAL=0.6 RISE=3 TARG v(v270) VAL=0.6 FALL=3

let freq = 1 / period_0

print SKEW0_90 SKEW90_180 SKEW180_270 SKEW270_0 phase0_90 phase90_180 phase180_270 phase270_0 PW0 PW90 PW180 PW270 freq

.endc

.lib cornerMOSlv.lib mos_tt
*.include /foss/pdks/ihp-sg13g2/libs.ref/sg13g2_stdcell/spice/sg13g2_stdcell.spice

**** end user architecture code
**.ends

* expanding   symbol:  /foss/designs/PhaseInterpolator/8xPI/8xPI.sym # of pins=9
** sym_path: /foss/designs/PhaseInterpolator/8xPI/8xPI.sym
** sch_path: /foss/designs/PhaseInterpolator/8xPI/8xPI.sch
.subckt 8xPI VINI VINIB VINQ VINQB VS[1] VS[0] VST[7] VST[6] VST[5] VST[4] VST[3] VST[2] VST[1] VST[0] VOUT VDD VSS
*.ipin VINI
*.ipin VINQ
*.ipin VINIB
*.ipin VINQB
*.iopin VDD
*.iopin VSS
*.opin VOUT
*.ipin VS[1],VS[0]
*.ipin VST[7],VST[6],VST[5],VST[4],VST[3],VST[2],VST[1],VST[0]
x1[7] VINI VINIB VDD net1 VS[1] VS[0] VINQ VSS VINQB VST[7] MUX_4_1
x1[6] VINI VINIB VDD net1 VS[1] VS[0] VINQ VSS VINQB VST[6] MUX_4_1
x1[5] VINI VINIB VDD net1 VS[1] VS[0] VINQ VSS VINQB VST[5] MUX_4_1
x1[4] VINI VINIB VDD net1 VS[1] VS[0] VINQ VSS VINQB VST[4] MUX_4_1
x1[3] VINI VINIB VDD net1 VS[1] VS[0] VINQ VSS VINQB VST[3] MUX_4_1
x1[2] VINI VINIB VDD net1 VS[1] VS[0] VINQ VSS VINQB VST[2] MUX_4_1
x1[1] VINI VINIB VDD net1 VS[1] VS[0] VINQ VSS VINQB VST[1] MUX_4_1
x1[0] VINI VINIB VDD net1 VS[1] VS[0] VINQ VSS VINQB VST[0] MUX_4_1
x2 VDD net2 net1 VSS inv_PI
x1 VDD VOUT net2 VSS buff_PI_d16
.ends

* expanding   symbol:  clock_gen.sym # of pins=7
** sym_path: /foss/designs/PhaseInterpolator/Clock_Gen/clock_gen.sym
** sch_path: /foss/designs/PhaseInterpolator/Clock_Gen/clock_gen.sch
.subckt clock_gen PH0 PH90 VDD CTRL PH180 VSS PH270
*.iopin VDD
*.iopin VSS
*.ipin CTRL
*.opin PH0
*.opin PH90
*.opin PH180
*.opin PH270
x1 CTRL v0 v3 v2 v5 v4 v1 VSS VDD 6ph_rosc
x16 VDD v4 v270 v5 VSS PI_clk
x2 VDD v1 v90 v2 VSS PI_clk
x8 VDD net9 v0 VSS inv_PI_d2
x9 VDD net10 v3 VSS inv_PI_d2
x10 VDD v360 net9 VSS inv_PI_d2
x11 VDD v180 net10 VSS inv_PI_d2
x3 VDD net6 v180 VSS buff_PI_d16
x4 VDD net7 v90 VSS buff_PI_d16
x5 VDD net5 v360 VSS buff_PI_d16
x6 VDD net8 v270 VSS buff_PI_d16
x7 VDD v180 v360 VSS flywheel_clk
x12 VDD v270 v90 VSS flywheel_clk
x13 VDD net2 net6 VSS inv_PI_d16
x14 VDD net3 net7 VSS inv_PI_d16
x15 VDD net4 net5 VSS inv_PI_d16
x17 VDD net1 net8 VSS inv_PI_d16
x18 VDD PH180 net2 VSS inv_PI_d32
x19 VDD PH90 net3 VSS inv_PI_d32
x20 VDD PH0 net4 VSS inv_PI_d32
x21 VDD PH270 net1 VSS inv_PI_d32
.ends

* expanding   symbol:  /foss/designs/PhaseInterpolator/Custom_std_cells/div_freq_x8.sym # of pins=4
** sym_path: /foss/designs/PhaseInterpolator/Custom_std_cells/div_freq_x8.sym
** sch_path: /foss/designs/PhaseInterpolator/Custom_std_cells/div_freq_x8.sch
.subckt div_freq_x8 VDD VINPI VOUT VSS
*.iopin VDD
*.iopin VSS
*.iopin VINPI
*.opin VOUT
x7 VDD VSS net1 VINPI div_freq_x2
x8 VDD VSS net2 net1 div_freq_x2
x9 VDD VSS VOUT net2 div_freq_x2
.ends

* expanding   symbol:  /foss/designs/PhaseInterpolator/Custom_std_cells/MUX_4_1.sym # of pins=9
** sym_path: /foss/designs/PhaseInterpolator/Custom_std_cells/MUX_4_1.sym
** sch_path: /foss/designs/PhaseInterpolator/Custom_std_cells/MUX_4_1.sch
.subckt MUX_4_1 VINA VINB VDD VOUT VS[1] VS[0] VINC VSS VIND VST
*.opin VOUT
*.iopin VDD
*.iopin VSS
*.ipin VINA
*.ipin VINB
*.ipin VINC
*.ipin VIND
*.ipin VS[1],VS[0]
*.ipin VST
x3 VDD VINC net2 VS[1] VIND VSS MUX_2_1
x4 VDD VINA net1 VS[0] VINB VSS MUX_2_1
x5 VDD net1 VOUT VST net2 VSS MUX_2_1
.ends

* expanding   symbol:  /foss/designs/PhaseInterpolator/Custom_std_cells/inv_PI.sym # of pins=4
** sym_path: /foss/designs/PhaseInterpolator/Custom_std_cells/inv_PI.sym
** sch_path: /foss/designs/PhaseInterpolator/Custom_std_cells/inv_PI.sch
.subckt inv_PI VDD VOUT VIN VSS
*.iopin VDD
*.iopin VSS
*.opin VOUT
*.ipin VIN
XM2 VOUT VIN VDD VDD sg13_lv_pmos w=0.45u l=0.13u ng=3 m=1
XM1 VOUT VIN VSS VSS sg13_lv_nmos w=0.3u l=0.13u ng=2 m=1
.ends

* expanding   symbol:  /foss/designs/PhaseInterpolator/Custom_std_cells/buff_PI_d16.sym # of pins=4
** sym_path: /foss/designs/PhaseInterpolator/Custom_std_cells/buff_PI_d16.sym
** sch_path: /foss/designs/PhaseInterpolator/Custom_std_cells/buff_PI_d16.sch
.subckt buff_PI_d16 VDD VOUT VIN VSS
*.ipin VIN
*.opin VOUT
*.iopin VDD
*.iopin VSS
x7 VDD net1 VIN VSS inv_PI_d2
x8 VDD net2 net1 VSS inv_PI_d4
x9 VDD net3 net2 VSS inv_PI_d8
x10 VDD VOUT net3 VSS inv_PI_d16
.ends

* expanding   symbol:  6ph_rosc.sym # of pins=9
** sym_path: /foss/designs/PhaseInterpolator/Clock_Gen/6ph_rosc.sym
** sch_path: /foss/designs/PhaseInterpolator/Clock_Gen/6ph_rosc.sch
.subckt 6ph_rosc CTRL Ph0 Ph3 Ph2 Ph5 Ph4 Ph1 VSS VDD
*.iopin VDD
*.iopin VSS
*.ipin CTRL
*.opin Ph0
*.opin Ph2
*.opin Ph5
*.opin Ph1
*.opin Ph4
*.opin Ph3
x1 VDD net1 net2 CTRL net6 net5 VSS psdiff
x2 VDD net3 net4 CTRL net2 net1 VSS psdiff
x3 VDD net5 net6 CTRL net4 net3 VSS psdiff
x4 CTRL Ph0 Ph3 VDD decap
x5 CTRL Ph2 Ph5 VDD decap
x6 CTRL Ph1 Ph4 VDD decap
x7 VDD Ph1 net2 VSS buff_d8
x8 VDD Ph4 net1 VSS buff_d8
x9 VDD Ph5 net4 VSS buff_d8
x10 VDD Ph2 net3 VSS buff_d8
x11 VDD Ph3 net6 VSS buff_d8
x12 VDD Ph0 net5 VSS buff_d8
x19 VDD Ph2 Ph5 VSS flywheel
x17 VDD Ph0 Ph3 VSS flywheel
x13 VDD Ph4 Ph1 VSS flywheel
.ends

* expanding   symbol:  PI_clk.sym # of pins=5
** sym_path: /foss/designs/PhaseInterpolator/Clock_Gen/PI_clk.sym
** sch_path: /foss/designs/PhaseInterpolator/Clock_Gen/PI_clk.sch
.subckt PI_clk VDD PH0 PHOUT PH1 VSS
*.iopin VDD
*.iopin VSS
*.ipin PH0
*.ipin PH1
*.opin PHOUT
x5 VDD net1 PH0 VSS inv_PI_d2
x6 VDD net1 PH1 VSS inv_PI_d2
x7 VDD PHOUT net1 VSS inv_PI_d2
.ends

* expanding   symbol:  /foss/designs/PhaseInterpolator/Custom_std_cells/inv_PI_d2.sym # of pins=4
** sym_path: /foss/designs/PhaseInterpolator/Custom_std_cells/inv_PI_d2.sym
** sch_path: /foss/designs/PhaseInterpolator/Custom_std_cells/inv_PI_d2.sch
.subckt inv_PI_d2 VDD VOUT VIN VSS
*.ipin VIN
*.opin VOUT
*.iopin VDD
*.iopin VSS
x1[1] VDD VOUT VIN VSS inv_PI
x1[0] VDD VOUT VIN VSS inv_PI
.ends

* expanding   symbol:  flywheel_clk.sym # of pins=4
** sym_path: /foss/designs/PhaseInterpolator/Clock_Gen/flywheel_clk.sym
** sch_path: /foss/designs/PhaseInterpolator/Clock_Gen/flywheel_clk.sch
.subckt flywheel_clk VDD PH1 PH0 VSS
*.iopin VDD
*.iopin VSS
*.iopin PH1
*.iopin PH0
x13 VDD PH1 PH0 VSS inv_d4
x14 VDD PH0 PH1 VSS inv_d2
.ends

* expanding   symbol:  /foss/designs/PhaseInterpolator/Custom_std_cells/inv_PI_d16.sym # of pins=4
** sym_path: /foss/designs/PhaseInterpolator/Custom_std_cells/inv_PI_d16.sym
** sch_path: /foss/designs/PhaseInterpolator/Custom_std_cells/inv_PI_d16.sch
.subckt inv_PI_d16 VDD VOUT VIN VSS
*.ipin VIN
*.opin VOUT
*.iopin VDD
*.iopin VSS
x1[1] VDD VOUT VIN VSS inv_PI_d8
x1[0] VDD VOUT VIN VSS inv_PI_d8
.ends

* expanding   symbol:  /foss/designs/PhaseInterpolator/Custom_std_cells/inv_PI_d32.sym # of pins=4
** sym_path: /foss/designs/PhaseInterpolator/Custom_std_cells/inv_PI_d32.sym
** sch_path: /foss/designs/PhaseInterpolator/Custom_std_cells/inv_PI_d32.sch
.subckt inv_PI_d32 VDD VOUT VIN VSS
*.ipin VIN
*.opin VOUT
*.iopin VDD
*.iopin VSS
x1[1] VDD VOUT VIN VSS inv_PI_d16
x1[0] VDD VOUT VIN VSS inv_PI_d16
.ends

* expanding   symbol:  /foss/designs/PhaseInterpolator/Custom_std_Cells/div_freq_x2.sym # of pins=4
** sym_path: /foss/designs/PhaseInterpolator/Custom_std_Cells/div_freq_x2.sym
** sch_path: /foss/designs/PhaseInterpolator/Custom_std_Cells/div_freq_x2.sch
.subckt div_freq_x2 VDD VSS CLKOUT CLKIN
*.iopin VDD
*.iopin VSS
*.ipin CLKIN
*.opin CLKOUT
x1 VDD CLKIN VSS CLKOUT net1 reg_v2
x4 VDD net1 CLKOUT VSS inv
.ends

* expanding   symbol:  /foss/designs/PhaseInterpolator/Custom_std_cells/MUX_2_1.sym # of pins=6
** sym_path: /foss/designs/PhaseInterpolator/Custom_std_cells/MUX_2_1.sym
** sch_path: /foss/designs/PhaseInterpolator/Custom_std_cells/MUX_2_1.sch
.subckt MUX_2_1 VDD VINA VOUT VS VINB VSS
*.opin VOUT
*.ipin VINA
*.ipin VINB
*.ipin VS
*.iopin VDD
*.iopin VSS
x1 net5 net1 VS net3 VDD VSS tg_custom
x8 net2 VS net1 net4 VDD VSS tg_custom
x3 VDD net1 VS VSS inv
x4 VDD net3 VINA VSS inv_PI
x5 VDD net4 VINB VSS inv_PI
x6[5] net5 VSS VDD net3 VDD VSS tg_custom
x6[4] net5 VSS VDD net3 VDD VSS tg_custom
x6[3] net5 VSS VDD net3 VDD VSS tg_custom
x6[2] net5 VSS VDD net3 VDD VSS tg_custom
x6[1] net5 VSS VDD net3 VDD VSS tg_custom
x6[0] net5 VSS VDD net3 VDD VSS tg_custom
x7[5] net2 VSS VDD net4 VDD VSS tg_custom
x7[4] net2 VSS VDD net4 VDD VSS tg_custom
x7[3] net2 VSS VDD net4 VDD VSS tg_custom
x7[2] net2 VSS VDD net4 VDD VSS tg_custom
x7[1] net2 VSS VDD net4 VDD VSS tg_custom
x7[0] net2 VSS VDD net4 VDD VSS tg_custom
x2 VOUT VDD VSS net5 VSS VDD tg_custom
x6 VOUT VDD VSS net2 VSS VDD tg_custom
.ends

* expanding   symbol:  /foss/designs/PhaseInterpolator/Custom_std_cells/inv_PI_d4.sym # of pins=4
** sym_path: /foss/designs/PhaseInterpolator/Custom_std_cells/inv_PI_d4.sym
** sch_path: /foss/designs/PhaseInterpolator/Custom_std_cells/inv_PI_d4.sch
.subckt inv_PI_d4 VDD VOUT VIN VSS
*.ipin VIN
*.opin VOUT
*.iopin VDD
*.iopin VSS
x1[1] VDD VOUT VIN VSS inv_PI_d2
x1[0] VDD VOUT VIN VSS inv_PI_d2
.ends

* expanding   symbol:  /foss/designs/PhaseInterpolator/Custom_std_cells/inv_PI_d8.sym # of pins=4
** sym_path: /foss/designs/PhaseInterpolator/Custom_std_cells/inv_PI_d8.sym
** sch_path: /foss/designs/PhaseInterpolator/Custom_std_cells/inv_PI_d8.sch
.subckt inv_PI_d8 VDD VOUT VIN VSS
*.ipin VIN
*.opin VOUT
*.iopin VDD
*.iopin VSS
x1[1] VDD VOUT VIN VSS inv_PI_d4
x1[0] VDD VOUT VIN VSS inv_PI_d4
.ends

* expanding   symbol:  psdiff.sym # of pins=7
** sym_path: /foss/designs/PhaseInterpolator/Clock_Gen/psdiff.sym
** sch_path: /foss/designs/PhaseInterpolator/Clock_Gen/psdiff.sch
.subckt psdiff VDD VOUTDN VOUTDP CTRL CLKN CLKP VSS
*.iopin VSS
*.ipin CLKP
*.ipin CLKN
*.iopin VDD
*.ipin CTRL
*.opin VOUTDN
*.opin VOUTDP
XM1 net1 CLKP VSS VSS sg13_lv_nmos w=1.5u l=0.13u ng=10 m=3
XM2 net2 CLKN VSS VSS sg13_lv_nmos w=1.5u l=0.13u ng=10 m=3
XM3 net3 CTRL net1 VSS sg13_lv_nmos w=0.3u l=0.13u ng=2 m=1
XM4 net4 CTRL net2 VSS sg13_lv_nmos w=0.3u l=0.13u ng=2 m=1
XM6 net2 net3 VDD VDD sg13_lv_pmos w=1.5u l=0.13u ng=10 m=1
XM5 net1 net4 VDD VDD sg13_lv_pmos w=1.5u l=0.13u ng=10 m=1
XM7 net1 VSS VDD VDD sg13_lv_pmos w=1.5u l=0.13u ng=10 m=2
XM8 net2 VSS VDD VDD sg13_lv_pmos w=1.5u l=0.13u ng=10 m=2
x1 VDD VOUTDP net2 VSS buff_d8
x2 VDD VOUTDN net1 VSS buff_d8
.ends

* expanding   symbol:  decap.sym # of pins=4
** sym_path: /foss/designs/PhaseInterpolator/Clock_Gen/decap.sym
** sch_path: /foss/designs/PhaseInterpolator/Clock_Gen/decap.sch
.subckt decap CTRL VOUTDN VOUTDP VDD
*.ipin CTRL
*.ipin VDD
*.ipin VOUTDN
*.ipin VOUTDP
XM10 CTRL VOUTDP CTRL VDD sg13_lv_pmos w=8u l=0.13u ng=8 m=4
XM9 CTRL VOUTDN CTRL VDD sg13_lv_pmos w=8u l=0.13u ng=8 m=4
.ends

* expanding   symbol:  /foss/designs/PhaseInterpolator/Custom_std_cells/buff_d8.sym # of pins=4
** sym_path: /foss/designs/PhaseInterpolator/Custom_std_cells/buff_d8.sym
** sch_path: /foss/designs/PhaseInterpolator/Custom_std_cells/buff_d8.sch
.subckt buff_d8 VDD VOUT VIN VSS
*.ipin VIN
*.opin VOUT
*.iopin VDD
*.iopin VSS
x7 VDD net1 VIN VSS inv
x8 VDD net2 net1 VSS inv_d2
x9 VDD net3 net2 VSS inv_d4
x10 VDD VOUT net3 VSS inv_d8
.ends

* expanding   symbol:  flywheel.sym # of pins=4
** sym_path: /foss/designs/PhaseInterpolator/Clock_Gen/flywheel.sym
** sch_path: /foss/designs/PhaseInterpolator/Clock_Gen/flywheel.sch
.subckt flywheel VDD PH1 PH0 VSS
*.iopin VDD
*.iopin VSS
*.iopin PH1
*.iopin PH0
x13 VDD PH1 PH0 VSS inv_d2
x14 VDD PH0 PH1 VSS inv_d2
.ends

* expanding   symbol:  /foss/designs/PhaseInterpolator/Custom_std_cells/inv_d4.sym # of pins=4
** sym_path: /foss/designs/PhaseInterpolator/Custom_std_cells/inv_d4.sym
** sch_path: /foss/designs/PhaseInterpolator/Custom_std_cells/inv_d4.sch
.subckt inv_d4 VDD VOUT VIN VSS
*.ipin VIN
*.opin VOUT
*.iopin VDD
*.iopin VSS
x1[1] VDD VOUT VIN VSS inv_d2
x1[0] VDD VOUT VIN VSS inv_d2
.ends

* expanding   symbol:  /foss/designs/PhaseInterpolator/Custom_std_cells/inv_d2.sym # of pins=4
** sym_path: /foss/designs/PhaseInterpolator/Custom_std_cells/inv_d2.sym
** sch_path: /foss/designs/PhaseInterpolator/Custom_std_cells/inv_d2.sch
.subckt inv_d2 VDD VOUT VIN VSS
*.ipin VIN
*.opin VOUT
*.iopin VDD
*.iopin VSS
x1[1] VDD VOUT VIN VSS inv
x1[0] VDD VOUT VIN VSS inv
.ends

* expanding   symbol:  /foss/designs/PhaseInterpolator/Custom_std_Cells/reg_v2.sym # of pins=5
** sym_path: /foss/designs/PhaseInterpolator/Custom_std_Cells/reg_v2.sym
** sch_path: /foss/designs/PhaseInterpolator/Custom_std_Cells/reg_v2.sch
.subckt reg_v2 VDD CLK VSS Q D
*.iopin VDD
*.iopin VSS
*.ipin CLK
*.ipin D
*.opin Q
x3 net7 CLK CLK_B net2 VDD VSS tg_custom
x9 VDD CLK_B CLK VSS inv
x4 VDD net2 net1 VSS inv
x8 VDD net4 D VSS inv
x11 VDD net3 Q VSS inv
x10 VDD net5 net1 VSS inv
x2 net7 CLK_B CLK net4 VDD VSS tg_custom
x6 net6 CLK_B CLK net3 VDD VSS tg_custom
x7 net6 CLK CLK_B net5 VDD VSS tg_custom
x5 VDD net1 net7 VSS inv
x1 VDD Q net6 VSS inv
.ends

* expanding   symbol:  /foss/designs/PhaseInterpolator/Custom_std_Cells/inv.sym # of pins=4
** sym_path: /foss/designs/PhaseInterpolator/Custom_std_Cells/inv.sym
** sch_path: /foss/designs/PhaseInterpolator/Custom_std_Cells/inv.sch
.subckt inv VDD VOUT VIN VSS
*.iopin VDD
*.iopin VSS
*.opin VOUT
*.ipin VIN
XM2 VOUT VIN VDD VDD sg13_lv_pmos w=0.15u l=0.13u ng=1 m=1
XM1 VOUT VIN VSS VSS sg13_lv_nmos w=0.15u l=0.13u ng=1 m=1
.ends

* expanding   symbol:  /foss/designs/PhaseInterpolator/Custom_std_cells/tg_custom.sym # of pins=6
** sym_path: /foss/designs/PhaseInterpolator/Custom_std_cells/tg_custom.sym
** sch_path: /foss/designs/PhaseInterpolator/Custom_std_cells/tg_custom.sch
.subckt tg_custom VOUT VSN VSP VIN VBP VBN
*.iopin VIN
*.iopin VSN
*.iopin VOUT
*.iopin VSP
*.iopin VBN
*.iopin VBP
XM1 VOUT VSN VIN VBN sg13_lv_nmos w=0.15u l=0.13u ng=1 m=1
XM2 VOUT VSP VIN VBP sg13_lv_pmos w=0.3u l=0.13u ng=2 m=1
.ends

* expanding   symbol:  /foss/designs/PhaseInterpolator/Custom_std_cells/inv_d8.sym # of pins=4
** sym_path: /foss/designs/PhaseInterpolator/Custom_std_cells/inv_d8.sym
** sch_path: /foss/designs/PhaseInterpolator/Custom_std_cells/inv_d8.sch
.subckt inv_d8 VDD VOUT VIN VSS
*.ipin VIN
*.opin VOUT
*.iopin VDD
*.iopin VSS
x1[1] VDD VOUT VIN VSS inv_d4
x1[0] VDD VOUT VIN VSS inv_d4
.ends

.GLOBAL GND
.end
