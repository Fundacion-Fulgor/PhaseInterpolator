** sch_path: /foss/designs/PhaseInterpolator/8xPI_top/tb_8xpi_linearity_integration.sch
**.subckt tb_8xpi_linearity_integration
x1 vdd v4 v3 v2 v1 v0 vout vcont vss 8xPI_top
Vin3 vinI GND dc 0 ac 0 pulse(0, 1.2, 0, 25p, 25p, 225p, 500p)
Vin5 vinIB GND dc 0 ac 0 pulse(0, 1.2, 250p, 25p, 25p, 225p, 500p )
x2 vdd vss vss vss vss vss vout8i vcont vss 8xPI_top
Vdd9 v1 VSS dc 0 ac 0 pulse(0, 1.2, 5n, 25p, 25p, 5n, 10n)
Vdd10 v2 VSS dc 0 ac 0 pulse(0, 1.2, 10n, 25p, 25p, 10n, 20n)
Vdd11 v0 VSS dc 0 ac 0 pulse(0, 1.2, 2.5n, 25p, 25p, 2.5n, 5n)
Vdd1 v3 VSS dc 0 ac 0 pulse(0, 1.2, 20n, 25p, 25p, 20n, 40n)
Vdd2 v4 VSS dc 0 ac 0 pulse(0, 1.2, 40n, 25p, 25p, 40n, 80n)
Vdd3 vdd GND 1.2
Vdd4 vcont GND 0.9
Vdd5 vss GND 0
**** begin user architecture code

* Circuit Parameters
.param vdd = 1.2
.param vss = 0.0
.param a=0
.param b=0
.param c=0
.param d=1
.param Tclk = 500P
.options TEMP = 27.0

* Include Models
*.lib /opt/pdks/ihp-sg13g2/libs.tech/ngspice/models/cornerMOSlv.lib mos_tt
*.lib /opt/pdks/ihp-sg13g2/libs.tech/ngspice/models/cornerMOShv.lib mos_tt
*.lib /opt/pdks/ihp-sg13g2/libs.tech/ngspice/models/cornerHBT.lib hbt_typ
*.lib /opt/pdks/ihp-sg13g2/libs.tech/ngspice/models/cornerRES.lib res_typ
.lib cornerMOSlv.lib mos_tt

* OP Parameters & Singals to save
.save V(vout) V(vout8i) V(vinI) V(vinIB) V(x1.vsq[2]) V(x1.vsq[1]) V(x1.vsq[0]) V(x1.vst[7]) V(x1.vst[6]) V(x1.vst[5]) V(x1.vst[4]) V(x1.vst[3]) V(x1.vst[2]) V(x1.vst[1]) V(x1.vstq[7]) V(x1.vstq[6]) V(x1.vstq[5]) V(x1.vstq[4]) V(x1.vstq[3]) V(x1.vstq[2]) V(x1.vstq[1]) V(x1.vi) V(x1.vib) V(x1.vq) V(x1.vqb)

*Simulations
.control
*set output_path = tb_linearity_8xpi/
	tran 5PS 80NS
	*setplot tran1
	*plot v0 v1+1.5 v0_st+3 v6_st+4.5 Vout+6 Vout8I+7.5 ylabel vout xlabel vin
	display
	set filetype = ascii
        write tran_linearity_integration.raw
	*V(vout) V(vout8i) V(vinI) V(vinIB) V(@x1.vsq[2]) V(x1.vst[7]) V(x1.vstq[7]) V(x1.x1.vini) V(x1.x1.vinib) V(x1.x1.vinq) V(x1.x1.vinqb)
	*write {$output_path}tran_linearity_termoless.raw V(Vout) V(Vout8I) V(vinI) V(VoutI1) V(VoutI2) V(VoutQ1) V(VoutIB1) V(VoutQB1)
.endc
.end

**** end user architecture code
**.ends

* expanding   symbol:  /foss/designs/PhaseInterpolator/8xPI_top/8xPI_top.sym # of pins=5
** sym_path: /foss/designs/PhaseInterpolator/8xPI_top/8xPI_top.sym
** sch_path: /foss/designs/PhaseInterpolator/8xPI_top/8xPI_top.sch
.subckt 8xPI_top VDD VS[4] VS[3] VS[2] VS[1] VS[0] VOUT VCONT VSS
*.ipin VCONT
*.iopin VDD
*.iopin VSS
*.opin VOUT
*.ipin VS[4],VS[3],VS[2],VS[1],VS[0]
x1 VI VIB VQ VQB VSQ[1] VSQ[0] VSTQ[7] VSTQ[6] VSTQ[5] VSTQ[4] VSTQ[3] VSTQ[2] VSTQ[1] VSQ[2] VOUT VDD VSS 8xPI
x2 VI VQ VDD VCONT VIB VSS VQB clock_gen
x3 VST[7] VST[6] VST[5] VST[4] VST[3] VST[2] VST[1] VS[2] VS[1] VS[0] VDD VSS 3to7_deco_v2
x4 VDD VSQ[2] VSQ[1] VSQ[0] VS[4] VS[3] VSS VSTQ[7] VSTQ[6] VSTQ[5] VSTQ[4] VSTQ[3] VSTQ[2] VSTQ[1] VST[7] VST[6] VST[5] VST[4]
+ VST[3] VST[2] VST[1] 8xPI_logic
.ends

* expanding   symbol:  /foss/designs/PhaseInterpolator/8xPI/8xPI.sym # of pins=9
** sym_path: /foss/designs/PhaseInterpolator/8xPI/8xPI.sym
** sch_path: /foss/designs/PhaseInterpolator/8xPI/8xPI.sch
.subckt 8xPI VINI VINIB VINQ VINQB VS[1] VS[0] VST[7] VST[6] VST[5] VST[4] VST[3] VST[2] VST[1] VST[0] VOUT VDD VSS
*.ipin VINI
*.ipin VINQ
*.ipin VINIB
*.ipin VINQB
*.iopin VDD
*.iopin VSS
*.opin VOUT
*.ipin VS[1],VS[0]
*.ipin VST[7],VST[6],VST[5],VST[4],VST[3],VST[2],VST[1],VST[0]
x1[7] VINI VINIB VDD net1 VS[1] VS[0] VINQ VSS VINQB VST[7] MUX_4_1
x1[6] VINI VINIB VDD net1 VS[1] VS[0] VINQ VSS VINQB VST[6] MUX_4_1
x1[5] VINI VINIB VDD net1 VS[1] VS[0] VINQ VSS VINQB VST[5] MUX_4_1
x1[4] VINI VINIB VDD net1 VS[1] VS[0] VINQ VSS VINQB VST[4] MUX_4_1
x1[3] VINI VINIB VDD net1 VS[1] VS[0] VINQ VSS VINQB VST[3] MUX_4_1
x1[2] VINI VINIB VDD net1 VS[1] VS[0] VINQ VSS VINQB VST[2] MUX_4_1
x1[1] VINI VINIB VDD net1 VS[1] VS[0] VINQ VSS VINQB VST[1] MUX_4_1
x1[0] VINI VINIB VDD net1 VS[1] VS[0] VINQ VSS VINQB VST[0] MUX_4_1
x2 VDD net2 net1 VSS inv_PI
x1 VDD VOUT net2 VSS buff_PI_d16
.ends

* expanding   symbol:  /foss/designs/PhaseInterpolator/Clock_gen/clock_gen.sym # of pins=7
** sym_path: /foss/designs/PhaseInterpolator/Clock_gen/clock_gen.sym
** sch_path: /foss/designs/PhaseInterpolator/Clock_gen/clock_gen.sch
.subckt clock_gen PH0 PH90 VDD CTRL PH180 VSS PH270
*.iopin VDD
*.iopin VSS
*.ipin CTRL
*.opin PH0
*.opin PH90
*.opin PH180
*.opin PH270
x1 CTRL v0 v3 v2 v5 v4 v1 VSS VDD 6ph_rosc
x16 VDD v4 v270 v5 VSS PI_clk
x2 VDD v1 v90 v2 VSS PI_clk
x8 VDD net9 v0 VSS inv_PI_d2
x9 VDD net10 v3 VSS inv_PI_d2
x10 VDD v360 net9 VSS inv_PI_d2
x11 VDD v180 net10 VSS inv_PI_d2
x3 VDD net6 v180 VSS buff_PI_d16
x4 VDD net7 v90 VSS buff_PI_d16
x5 VDD net5 v360 VSS buff_PI_d16
x6 VDD net8 v270 VSS buff_PI_d16
x7 VDD v180 v360 VSS flywheel_clk
x12 VDD v270 v90 VSS flywheel_clk
x13 VDD net2 net6 VSS inv_PI_d16
x14 VDD net3 net7 VSS inv_PI_d16
x15 VDD net4 net5 VSS inv_PI_d16
x17 VDD net1 net8 VSS inv_PI_d16
x18 VDD PH180 net2 VSS inv_PI_d32
x19 VDD PH90 net3 VSS inv_PI_d32
x20 VDD PH0 net4 VSS inv_PI_d32
x21 VDD PH270 net1 VSS inv_PI_d32
.ends

* expanding   symbol:  /foss/designs/PhaseInterpolator/BinarytoThermo/3to7_deco_v2.sym # of pins=4
** sym_path: /foss/designs/PhaseInterpolator/BinarytoThermo/3to7_deco_v2.sym
** sch_path: /foss/designs/PhaseInterpolator/BinarytoThermo/3to7_deco_v2.sch
.subckt 3to7_deco_v2 ST[7] ST[6] ST[5] ST[4] ST[3] ST[2] ST[1] S[2] S[1] S[0] VDD VSS
*.opin ST[7],ST[6],ST[5],ST[4],ST[3],ST[2],ST[1]
*.ipin S[2],S[1],S[0]
*.iopin VDD
*.iopin VSS
x1 VDD net3 S[2] VSS inv
x2 VDD net2 S[1] VSS inv
x3 VDD net1 S[0] VSS inv
x4 VDD net1 net2 net3 ST[1] VSS nor_x3_custom
x5 VDD net2 ST[2] net3 VSS nor_custom
x6 VDD net5 ST[3] net3 VSS nor_custom
x7 VDD ST[4] net3 VSS inv
x8 VDD ST[5] net4 net3 VSS nand_custom
x9 VDD ST[6] net2 net3 VSS nand_custom
x11 VDD net5 net2 net1 VSS and_custom
x12 VDD net1 net4 net2 VSS or_custom
x10 VDD ST[7] net1 net2 net3 VSS nand_x3_custom
.ends

* expanding   symbol:  /foss/designs/PhaseInterpolator/8xPI_logic/8xPI_logic.sym # of pins=6
** sym_path: /foss/designs/PhaseInterpolator/8xPI_logic/8xPI_logic.sym
** sch_path: /foss/designs/PhaseInterpolator/8xPI_logic/8xPI_logic.sch
.subckt 8xPI_logic VDD SQ[2] SQ[1] SQ[0] S[4] S[3] VSS STQ[7] STQ[6] STQ[5] STQ[4] STQ[3] STQ[2] STQ[1] ST[7] ST[6] ST[5] ST[4]
+ ST[3] ST[2] ST[1]
*.ipin S[4],S[3]
*.iopin VSS
*.opin STQ[7],STQ[6],STQ[5],STQ[4],STQ[3],STQ[2],STQ[1]
*.ipin ST[7],ST[6],ST[5],ST[4],ST[3],ST[2],ST[1]
*.iopin VDD
*.opin SQ[2],SQ[1],SQ[0]
x1 VDD net1 S[4] VSS inv
x2 VDD SQ[1] net1 VSS inv
x3 VDD S[3] VSS SQ[0] S[4] xor_custom
x4 VDD net2 S[3] VSS inv
x5 VDD SQ[2] net2 VSS inv
x6[6] VDD SCb[7] Sbuff[3] VSS inv
x6[5] VDD SCb[6] Sbuff[3] VSS inv
x6[4] VDD SCb[5] Sbuff[3] VSS inv
x6[3] VDD SCb[4] Sbuff[3] VSS inv
x6[2] VDD SCb[3] Sbuff[3] VSS inv
x6[1] VDD SCb[2] Sbuff[3] VSS inv
x6[0] VDD SCb[1] Sbuff[3] VSS inv
x7[6] VDD SC[7] SCb[7] VSS inv
x7[5] VDD SC[6] SCb[6] VSS inv
x7[4] VDD SC[5] SCb[5] VSS inv
x7[3] VDD SC[4] SCb[4] VSS inv
x7[2] VDD SC[3] SCb[3] VSS inv
x7[1] VDD SC[2] SCb[2] VSS inv
x7[0] VDD SC[1] SCb[1] VSS inv
x1[6] VDD ST[7] VSS STQ[7] SC[7] xor_custom
x1[5] VDD ST[6] VSS STQ[6] SC[6] xor_custom
x1[4] VDD ST[5] VSS STQ[5] SC[5] xor_custom
x1[3] VDD ST[4] VSS STQ[4] SC[4] xor_custom
x1[2] VDD ST[3] VSS STQ[3] SC[3] xor_custom
x1[1] VDD ST[2] VSS STQ[2] SC[2] xor_custom
x1[0] VDD ST[1] VSS STQ[1] SC[1] xor_custom
x6 VDD Sbuff[3] S[3] VSS buff_d8
.ends

* expanding   symbol:  /foss/designs/PhaseInterpolator/Custom_std_cells/MUX_4_1.sym # of pins=9
** sym_path: /foss/designs/PhaseInterpolator/Custom_std_cells/MUX_4_1.sym
** sch_path: /foss/designs/PhaseInterpolator/Custom_std_cells/MUX_4_1.sch
.subckt MUX_4_1 VINA VINB VDD VOUT VS[1] VS[0] VINC VSS VIND VST
*.opin VOUT
*.iopin VDD
*.iopin VSS
*.ipin VINA
*.ipin VINB
*.ipin VINC
*.ipin VIND
*.ipin VS[1],VS[0]
*.ipin VST
x3 VDD VINC net2 VS[1] VIND VSS MUX_2_1
x4 VDD VINA net1 VS[0] VINB VSS MUX_2_1
x5 VDD net1 VOUT VST net2 VSS MUX_2_1
.ends

* expanding   symbol:  /foss/designs/PhaseInterpolator/Custom_std_cells/inv_PI.sym # of pins=4
** sym_path: /foss/designs/PhaseInterpolator/Custom_std_cells/inv_PI.sym
** sch_path: /foss/designs/PhaseInterpolator/Custom_std_cells/inv_PI.sch
.subckt inv_PI VDD VOUT VIN VSS
*.iopin VDD
*.iopin VSS
*.opin VOUT
*.ipin VIN
XM2 VOUT VIN VDD VDD sg13_lv_pmos w=0.45u l=0.13u ng=3 m=1
XM1 VOUT VIN VSS VSS sg13_lv_nmos w=0.3u l=0.13u ng=2 m=1
.ends

* expanding   symbol:  /foss/designs/PhaseInterpolator/Custom_std_cells/buff_PI_d16.sym # of pins=4
** sym_path: /foss/designs/PhaseInterpolator/Custom_std_cells/buff_PI_d16.sym
** sch_path: /foss/designs/PhaseInterpolator/Custom_std_cells/buff_PI_d16.sch
.subckt buff_PI_d16 VDD VOUT VIN VSS
*.ipin VIN
*.opin VOUT
*.iopin VDD
*.iopin VSS
x7 VDD net1 VIN VSS inv_PI_d2
x8 VDD net2 net1 VSS inv_PI_d4
x9 VDD net3 net2 VSS inv_PI_d8
x10 VDD VOUT net3 VSS inv_PI_d16
.ends

* expanding   symbol:  6ph_rosc.sym # of pins=9
** sym_path: /foss/designs/PhaseInterpolator/Clock_Gen/6ph_rosc.sym
** sch_path: /foss/designs/PhaseInterpolator/Clock_Gen/6ph_rosc.sch
.subckt 6ph_rosc CTRL Ph0 Ph3 Ph2 Ph5 Ph4 Ph1 VSS VDD
*.iopin VDD
*.iopin VSS
*.ipin CTRL
*.opin Ph0
*.opin Ph2
*.opin Ph5
*.opin Ph1
*.opin Ph4
*.opin Ph3
x1 VDD net1 net2 CTRL net6 net5 VSS psdiff
x2 VDD net3 net4 CTRL net2 net1 VSS psdiff
x3 VDD net5 net6 CTRL net4 net3 VSS psdiff
x4 CTRL Ph0 Ph3 VDD decap
x5 CTRL Ph2 Ph5 VDD decap
x6 CTRL Ph1 Ph4 VDD decap
x7 VDD Ph1 net2 VSS buff_d8
x8 VDD Ph4 net1 VSS buff_d8
x9 VDD Ph5 net4 VSS buff_d8
x10 VDD Ph2 net3 VSS buff_d8
x11 VDD Ph3 net6 VSS buff_d8
x12 VDD Ph0 net5 VSS buff_d8
x19 VDD Ph2 Ph5 VSS flywheel
x17 VDD Ph0 Ph3 VSS flywheel
x13 VDD Ph4 Ph1 VSS flywheel
.ends

* expanding   symbol:  PI_clk.sym # of pins=5
** sym_path: /foss/designs/PhaseInterpolator/Clock_Gen/PI_clk.sym
** sch_path: /foss/designs/PhaseInterpolator/Clock_Gen/PI_clk.sch
.subckt PI_clk VDD PH0 PHOUT PH1 VSS
*.iopin VDD
*.iopin VSS
*.ipin PH0
*.ipin PH1
*.opin PHOUT
x5 VDD net1 PH0 VSS inv_PI_d2
x6 VDD net1 PH1 VSS inv_PI_d2
x7 VDD PHOUT net1 VSS inv_PI_d2
.ends

* expanding   symbol:  /foss/designs/PhaseInterpolator/Custom_std_cells/inv_PI_d2.sym # of pins=4
** sym_path: /foss/designs/PhaseInterpolator/Custom_std_cells/inv_PI_d2.sym
** sch_path: /foss/designs/PhaseInterpolator/Custom_std_cells/inv_PI_d2.sch
.subckt inv_PI_d2 VDD VOUT VIN VSS
*.ipin VIN
*.opin VOUT
*.iopin VDD
*.iopin VSS
x1[1] VDD VOUT VIN VSS inv_PI
x1[0] VDD VOUT VIN VSS inv_PI
.ends

* expanding   symbol:  flywheel_clk.sym # of pins=4
** sym_path: /foss/designs/PhaseInterpolator/Clock_Gen/flywheel_clk.sym
** sch_path: /foss/designs/PhaseInterpolator/Clock_Gen/flywheel_clk.sch
.subckt flywheel_clk VDD PH1 PH0 VSS
*.iopin VDD
*.iopin VSS
*.iopin PH1
*.iopin PH0
x13 VDD PH1 PH0 VSS inv_d4
x14 VDD PH0 PH1 VSS inv_d2
.ends

* expanding   symbol:  /foss/designs/PhaseInterpolator/Custom_std_cells/inv_PI_d16.sym # of pins=4
** sym_path: /foss/designs/PhaseInterpolator/Custom_std_cells/inv_PI_d16.sym
** sch_path: /foss/designs/PhaseInterpolator/Custom_std_cells/inv_PI_d16.sch
.subckt inv_PI_d16 VDD VOUT VIN VSS
*.ipin VIN
*.opin VOUT
*.iopin VDD
*.iopin VSS
x1[1] VDD VOUT VIN VSS inv_PI_d8
x1[0] VDD VOUT VIN VSS inv_PI_d8
.ends

* expanding   symbol:  /foss/designs/PhaseInterpolator/Custom_std_cells/inv_PI_d32.sym # of pins=4
** sym_path: /foss/designs/PhaseInterpolator/Custom_std_cells/inv_PI_d32.sym
** sch_path: /foss/designs/PhaseInterpolator/Custom_std_cells/inv_PI_d32.sch
.subckt inv_PI_d32 VDD VOUT VIN VSS
*.ipin VIN
*.opin VOUT
*.iopin VDD
*.iopin VSS
x1[1] VDD VOUT VIN VSS inv_PI_d16
x1[0] VDD VOUT VIN VSS inv_PI_d16
.ends

* expanding   symbol:  /foss/designs/PhaseInterpolator/Custom_std_cells/inv.sym # of pins=4
** sym_path: /foss/designs/PhaseInterpolator/Custom_std_cells/inv.sym
** sch_path: /foss/designs/PhaseInterpolator/Custom_std_cells/inv.sch
.subckt inv VDD VOUT VIN VSS
*.iopin VDD
*.iopin VSS
*.opin VOUT
*.ipin VIN
XM2 VOUT VIN VDD VDD sg13_lv_pmos w=0.15u l=0.13u ng=1 m=1
XM1 VOUT VIN VSS VSS sg13_lv_nmos w=0.15u l=0.13u ng=1 m=1
.ends

* expanding   symbol:  /foss/designs/PhaseInterpolator/Custom_std_cells/nor_x3_custom.sym # of pins=6
** sym_path: /foss/designs/PhaseInterpolator/Custom_std_cells/nor_x3_custom.sym
** sch_path: /foss/designs/PhaseInterpolator/Custom_std_cells/nor_x3_custom.sch
.subckt nor_x3_custom VDD A B C OUT VSS
*.iopin VDD
*.iopin VSS
*.ipin B
*.ipin C
*.opin OUT
*.ipin A
XM1 OUT A VSS VSS sg13_lv_nmos w=0.15u l=0.13u ng=1 m=1
XM2 OUT C net1 VDD sg13_lv_pmos w=0.15u l=0.13u ng=1 m=1
XM3 OUT B VSS VSS sg13_lv_nmos w=0.15u l=0.13u ng=1 m=1
XM4 net1 B net2 VDD sg13_lv_pmos w=0.15u l=0.13u ng=1 m=1
XM5 net2 A VDD VDD sg13_lv_pmos w=0.15u l=0.13u ng=1 m=1
XM6 OUT C VSS VSS sg13_lv_nmos w=0.15u l=0.13u ng=1 m=1
.ends

* expanding   symbol:  /foss/designs/PhaseInterpolator/Custom_std_cells/nor_custom.sym # of pins=5
** sym_path: /foss/designs/PhaseInterpolator/Custom_std_cells/nor_custom.sym
** sch_path: /foss/designs/PhaseInterpolator/Custom_std_cells/nor_custom.sch
.subckt nor_custom VDD A OUT B VSS
*.iopin VDD
*.iopin VSS
*.ipin A
*.ipin B
*.opin OUT
XM1 OUT A VSS VSS sg13_lv_nmos w=0.15u l=0.13u ng=1 m=1
XM2 OUT B net1 VDD sg13_lv_pmos w=0.15u l=0.13u ng=1 m=1
XM3 OUT B VSS VSS sg13_lv_nmos w=0.15u l=0.13u ng=1 m=1
XM4 net1 A VDD VDD sg13_lv_pmos w=0.15u l=0.13u ng=1 m=1
.ends

* expanding   symbol:  /foss/designs/PhaseInterpolator/Custom_std_cells/nand_custom.sym # of pins=5
** sym_path: /foss/designs/PhaseInterpolator/Custom_std_cells/nand_custom.sym
** sch_path: /foss/designs/PhaseInterpolator/Custom_std_cells/nand_custom.sch
.subckt nand_custom VDD OUT A B VSS
*.iopin VDD
*.iopin VSS
*.ipin A
*.ipin B
*.opin OUT
XM1 OUT A net1 VSS sg13_lv_nmos w=0.15u l=0.13u ng=1 m=1
XM2 OUT A VDD VDD sg13_lv_pmos w=0.15u l=0.13u ng=1 m=1
XM3 net1 B VSS VSS sg13_lv_nmos w=0.15u l=0.13u ng=1 m=1
XM4 OUT B VDD VDD sg13_lv_pmos w=0.15u l=0.13u ng=1 m=1
.ends

* expanding   symbol:  /foss/designs/PhaseInterpolator/Custom_std_cells/and_custom.sym # of pins=5
** sym_path: /foss/designs/PhaseInterpolator/Custom_std_cells/and_custom.sym
** sch_path: /foss/designs/PhaseInterpolator/Custom_std_cells/and_custom.sch
.subckt and_custom VDD OUT A B VSS
*.ipin A
*.iopin VDD
*.opin OUT
*.iopin VSS
*.ipin B
x1 VDD OUT net1 VSS inv
x2 VDD net1 A B VSS nand_custom
.ends

* expanding   symbol:  /foss/designs/PhaseInterpolator/Custom_std_cells/or_custom.sym # of pins=5
** sym_path: /foss/designs/PhaseInterpolator/Custom_std_cells/or_custom.sym
** sch_path: /foss/designs/PhaseInterpolator/Custom_std_cells/or_custom.sch
.subckt or_custom VDD A OUT B VSS
*.iopin VDD
*.iopin VSS
*.opin OUT
*.ipin A
*.ipin B
x1 VDD A net1 B VSS nor_custom
x2 VDD OUT net1 VSS inv
.ends

* expanding   symbol:  /foss/designs/PhaseInterpolator/Custom_std_cells/nand_x3_custom.sym # of pins=6
** sym_path: /foss/designs/PhaseInterpolator/Custom_std_cells/nand_x3_custom.sym
** sch_path: /foss/designs/PhaseInterpolator/Custom_std_cells/nand_x3_custom.sch
.subckt nand_x3_custom VDD OUT A B C VSS
*.ipin A
*.ipin B
*.ipin C
*.iopin VSS
*.iopin VDD
*.opin OUT
XM2 OUT A VDD VDD sg13_lv_pmos w=0.15u l=0.13u ng=1 m=1
XM1 OUT B VDD VDD sg13_lv_pmos w=0.15u l=0.13u ng=1 m=1
XM3 OUT C VDD VDD sg13_lv_pmos w=0.15u l=0.13u ng=1 m=1
XM4 OUT A net1 VSS sg13_lv_nmos w=0.15u l=0.13u ng=1 m=1
XM5 net1 B net2 VSS sg13_lv_nmos w=0.15u l=0.13u ng=1 m=1
XM6 net2 C VSS VSS sg13_lv_nmos w=0.15u l=0.13u ng=1 m=1
.ends

* expanding   symbol:  /foss/designs/PhaseInterpolator/Custom_std_cells/xor_custom.sym # of pins=5
** sym_path: /foss/designs/PhaseInterpolator/Custom_std_cells/xor_custom.sym
** sch_path: /foss/designs/PhaseInterpolator/Custom_std_cells/xor_custom.sch
.subckt xor_custom VDD B VSS VOUT A
*.ipin A
*.ipin B
*.opin VOUT
*.iopin VDD
*.iopin VSS
x1 VDD Bb B VSS inv
x3 A Bb B VOUT VDD VSS tg_custom
x2 B VDD A VSS Bb VOUT inv_xor
.ends

* expanding   symbol:  /foss/designs/PhaseInterpolator/Custom_std_cells/buff_d8.sym # of pins=4
** sym_path: /foss/designs/PhaseInterpolator/Custom_std_cells/buff_d8.sym
** sch_path: /foss/designs/PhaseInterpolator/Custom_std_cells/buff_d8.sch
.subckt buff_d8 VDD VOUT VIN VSS
*.ipin VIN
*.opin VOUT
*.iopin VDD
*.iopin VSS
x7 VDD net1 VIN VSS inv
x8 VDD net2 net1 VSS inv_d2
x9 VDD net3 net2 VSS inv_d4
x10 VDD VOUT net3 VSS inv_d8
.ends

* expanding   symbol:  /foss/designs/PhaseInterpolator/Custom_std_cells/MUX_2_1.sym # of pins=6
** sym_path: /foss/designs/PhaseInterpolator/Custom_std_cells/MUX_2_1.sym
** sch_path: /foss/designs/PhaseInterpolator/Custom_std_cells/MUX_2_1.sch
.subckt MUX_2_1 VDD VINA VOUT VS VINB VSS
*.opin VOUT
*.ipin VINA
*.ipin VINB
*.ipin VS
*.iopin VDD
*.iopin VSS
x1 net5 net1 VS net3 VDD VSS tg_custom
x8 net2 VS net1 net4 VDD VSS tg_custom
x3 VDD net1 VS VSS inv
x4 VDD net3 VINA VSS inv_PI
x5 VDD net4 VINB VSS inv_PI
x6[5] net5 VSS VDD net3 VDD VSS tg_custom
x6[4] net5 VSS VDD net3 VDD VSS tg_custom
x6[3] net5 VSS VDD net3 VDD VSS tg_custom
x6[2] net5 VSS VDD net3 VDD VSS tg_custom
x6[1] net5 VSS VDD net3 VDD VSS tg_custom
x6[0] net5 VSS VDD net3 VDD VSS tg_custom
x7[5] net2 VSS VDD net4 VDD VSS tg_custom
x7[4] net2 VSS VDD net4 VDD VSS tg_custom
x7[3] net2 VSS VDD net4 VDD VSS tg_custom
x7[2] net2 VSS VDD net4 VDD VSS tg_custom
x7[1] net2 VSS VDD net4 VDD VSS tg_custom
x7[0] net2 VSS VDD net4 VDD VSS tg_custom
x2 VOUT VDD VSS net5 VSS VDD tg_custom
x6 VOUT VDD VSS net2 VSS VDD tg_custom
.ends

* expanding   symbol:  /foss/designs/PhaseInterpolator/Custom_std_cells/inv_PI_d4.sym # of pins=4
** sym_path: /foss/designs/PhaseInterpolator/Custom_std_cells/inv_PI_d4.sym
** sch_path: /foss/designs/PhaseInterpolator/Custom_std_cells/inv_PI_d4.sch
.subckt inv_PI_d4 VDD VOUT VIN VSS
*.ipin VIN
*.opin VOUT
*.iopin VDD
*.iopin VSS
x1[1] VDD VOUT VIN VSS inv_PI_d2
x1[0] VDD VOUT VIN VSS inv_PI_d2
.ends

* expanding   symbol:  /foss/designs/PhaseInterpolator/Custom_std_cells/inv_PI_d8.sym # of pins=4
** sym_path: /foss/designs/PhaseInterpolator/Custom_std_cells/inv_PI_d8.sym
** sch_path: /foss/designs/PhaseInterpolator/Custom_std_cells/inv_PI_d8.sch
.subckt inv_PI_d8 VDD VOUT VIN VSS
*.ipin VIN
*.opin VOUT
*.iopin VDD
*.iopin VSS
x1[1] VDD VOUT VIN VSS inv_PI_d4
x1[0] VDD VOUT VIN VSS inv_PI_d4
.ends

* expanding   symbol:  psdiff.sym # of pins=7
** sym_path: /foss/designs/PhaseInterpolator/Clock_Gen/psdiff.sym
** sch_path: /foss/designs/PhaseInterpolator/Clock_Gen/psdiff.sch
.subckt psdiff VDD VOUTDN VOUTDP CTRL CLKN CLKP VSS
*.iopin VSS
*.ipin CLKP
*.ipin CLKN
*.iopin VDD
*.ipin CTRL
*.opin VOUTDN
*.opin VOUTDP
XM1 net1 CLKP VSS VSS sg13_lv_nmos w=1.5u l=0.13u ng=10 m=3
XM2 net2 CLKN VSS VSS sg13_lv_nmos w=1.5u l=0.13u ng=10 m=3
XM3 net3 CTRL net1 VSS sg13_lv_nmos w=0.3u l=0.13u ng=2 m=1
XM4 net4 CTRL net2 VSS sg13_lv_nmos w=0.3u l=0.13u ng=2 m=1
XM6 net2 net3 VDD VDD sg13_lv_pmos w=1.5u l=0.13u ng=10 m=1
XM5 net1 net4 VDD VDD sg13_lv_pmos w=1.5u l=0.13u ng=10 m=1
XM7 net1 VSS VDD VDD sg13_lv_pmos w=1.5u l=0.13u ng=10 m=2
XM8 net2 VSS VDD VDD sg13_lv_pmos w=1.5u l=0.13u ng=10 m=2
x1 VDD VOUTDP net2 VSS buff_d8
x2 VDD VOUTDN net1 VSS buff_d8
.ends

* expanding   symbol:  decap.sym # of pins=4
** sym_path: /foss/designs/PhaseInterpolator/Clock_Gen/decap.sym
** sch_path: /foss/designs/PhaseInterpolator/Clock_Gen/decap.sch
.subckt decap CTRL VOUTDN VOUTDP VDD
*.ipin CTRL
*.ipin VDD
*.ipin VOUTDN
*.ipin VOUTDP
XM10 CTRL VOUTDP CTRL VDD sg13_lv_pmos w=8u l=0.13u ng=8 m=4
XM9 CTRL VOUTDN CTRL VDD sg13_lv_pmos w=8u l=0.13u ng=8 m=4
.ends

* expanding   symbol:  flywheel.sym # of pins=4
** sym_path: /foss/designs/PhaseInterpolator/Clock_Gen/flywheel.sym
** sch_path: /foss/designs/PhaseInterpolator/Clock_Gen/flywheel.sch
.subckt flywheel VDD PH1 PH0 VSS
*.iopin VDD
*.iopin VSS
*.iopin PH1
*.iopin PH0
x13 VDD PH1 PH0 VSS inv_d2
x14 VDD PH0 PH1 VSS inv_d2
.ends

* expanding   symbol:  /foss/designs/PhaseInterpolator/Custom_std_cells/inv_d4.sym # of pins=4
** sym_path: /foss/designs/PhaseInterpolator/Custom_std_cells/inv_d4.sym
** sch_path: /foss/designs/PhaseInterpolator/Custom_std_cells/inv_d4.sch
.subckt inv_d4 VDD VOUT VIN VSS
*.ipin VIN
*.opin VOUT
*.iopin VDD
*.iopin VSS
x1[1] VDD VOUT VIN VSS inv_d2
x1[0] VDD VOUT VIN VSS inv_d2
.ends

* expanding   symbol:  /foss/designs/PhaseInterpolator/Custom_std_cells/inv_d2.sym # of pins=4
** sym_path: /foss/designs/PhaseInterpolator/Custom_std_cells/inv_d2.sym
** sch_path: /foss/designs/PhaseInterpolator/Custom_std_cells/inv_d2.sch
.subckt inv_d2 VDD VOUT VIN VSS
*.ipin VIN
*.opin VOUT
*.iopin VDD
*.iopin VSS
x1[1] VDD VOUT VIN VSS inv
x1[0] VDD VOUT VIN VSS inv
.ends

* expanding   symbol:  /foss/designs/PhaseInterpolator/Custom_std_Cells/tg_custom.sym # of pins=6
** sym_path: /foss/designs/PhaseInterpolator/Custom_std_Cells/tg_custom.sym
** sch_path: /foss/designs/PhaseInterpolator/Custom_std_Cells/tg_custom.sch
.subckt tg_custom VOUT VSN VSP VIN VBP VBN
*.iopin VIN
*.iopin VSN
*.iopin VOUT
*.iopin VSP
*.iopin VBN
*.iopin VBP
XM1 VOUT VSN VIN VBN sg13_lv_nmos w=0.15u l=0.13u ng=1 m=1
XM2 VOUT VSP VIN VBP sg13_lv_pmos w=0.3u l=0.13u ng=2 m=1
.ends

* expanding   symbol:  /foss/designs/PhaseInterpolator/Custom_std_Cells/inv_xor.sym # of pins=6
** sym_path: /foss/designs/PhaseInterpolator/Custom_std_Cells/inv_xor.sym
** sch_path: /foss/designs/PhaseInterpolator/Custom_std_Cells/inv_xor.sch
.subckt inv_xor VDD VBP VIN VBN VSS VOUT
*.iopin VDD
*.iopin VSS
*.opin VOUT
*.ipin VIN
*.iopin VBP
*.iopin VBN
XM2 VOUT VIN VDD VBP sg13_lv_pmos w=0.15u l=0.13u ng=1 m=1
XM1 VOUT VIN VSS VBN sg13_lv_nmos w=0.15u l=0.13u ng=1 m=1
.ends

* expanding   symbol:  /foss/designs/PhaseInterpolator/Custom_std_cells/inv_d8.sym # of pins=4
** sym_path: /foss/designs/PhaseInterpolator/Custom_std_cells/inv_d8.sym
** sch_path: /foss/designs/PhaseInterpolator/Custom_std_cells/inv_d8.sch
.subckt inv_d8 VDD VOUT VIN VSS
*.ipin VIN
*.opin VOUT
*.iopin VDD
*.iopin VSS
x1[1] VDD VOUT VIN VSS inv_d4
x1[0] VDD VOUT VIN VSS inv_d4
.ends

.GLOBAL GND
.end
