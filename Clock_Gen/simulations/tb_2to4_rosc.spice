** sch_path: /foss/designs/PhaseInterpolator/2to4/tb_2to4_rosc.sch
**.subckt tb_2to4_rosc
x1 vc v0 v3 v2 v5 v4 v1 vss vdd 2to4_rosc
Vdd4 vc GND 0.9
Vdd3 vss GND 0
Vdd1 vdd GND 1.2
x2 vdd net1 v1 vss inv_PI_d2
x3 vdd net1 v2 vss inv_PI_d2
x4 vdd v90 net1 vss inv_PI_d2
x5 vdd net2 v4 vss inv_PI_d2
x6 vdd net2 v5 vss inv_PI_d2
x7 vdd v270 net2 vss inv_PI_d2
x8 vdd net3 v0 vss inv_PI_d2
x9 vdd net4 v3 vss inv_PI_d2
x10 vdd v0_ net3 vss inv_PI_d2
x11 vdd v180 net4 vss inv_PI_d2
x13 VDD v180 v0_ VSS inv_PI_d2
x14 VDD v0_ v180 VSS inv_PI_d2
x12 VDD v270 v90 VSS inv_PI_d2
x15 VDD v90 v270 VSS inv_PI_d2
**** begin user architecture code

.lib cornerMOSlv.lib mos_tt
*.include /foss/pdks/ihp-sg13g2/libs.ref/sg13g2_stdcell/spice/sg13g2_stdcell.spice

.save v(v0) v(v1) v(v2) v(v3) v(v4) v(v5) v(v90) v(v270) v(v0_) v(v180)

.tran 2p 5n

.control
run
set color0=white
write rosc.raw

meas tran SKEW0_1 TRIG v(v0) VAL=0.6 RISE=3 TARG v(v1) VAL=0.6 RISE=4
meas tran SKEW1_2 TRIG v(v1) VAL=0.6 RISE=3 TARG v(v2) VAL=0.6 RISE=4
meas tran SKEW2_3 TRIG v(v2) VAL=0.6 RISE=3 TARG v(v3) VAL=0.6 RISE=4
meas tran SKEW3_4 TRIG v(v3) VAL=0.6 RISE=3 TARG v(v4) VAL=0.6 RISE=5
meas tran SKEW4_5 TRIG v(v4) VAL=0.6 RISE=3 TARG v(v5) VAL=0.6 RISE=4
meas tran SKEW5_0 TRIG v(v5) VAL=0.6 RISE=3 TARG v(v0) VAL=0.6 RISE=4

meas tran T0 TRIG v(v0) VAL=0.6 RISE=3 TARG v(v0) VAL=0.6 RISE=4
meas tran T1 TRIG v(v1) VAL=0.6 RISE=3 TARG v(v1) VAL=0.6 RISE=4
meas tran T2 TRIG v(v2) VAL=0.6 RISE=3 TARG v(v2) VAL=0.6 RISE=4
meas tran T3 TRIG v(v3) VAL=0.6 RISE=3 TARG v(v3) VAL=0.6 RISE=4
meas tran T4 TRIG v(v4) VAL=0.6 RISE=3 TARG v(v4) VAL=0.6 RISE=4
meas tran T5 TRIG v(v5) VAL=0.6 RISE=3 TARG v(v5) VAL=0.6 RISE=4

let period_0 = T0
let period_1 = T1
let period_2 = T2
let period_3 = T3
let period_4 = T4
let period_5 = T5

let phase0_1 = ((SKEW0_1 / period_0) * 360) -360
let phase1_2 = ((SKEW1_2 / period_0) * 360) -360
let phase2_3 = ((SKEW2_3 / period_0) * 360) -360
let phase3_4 = ((SKEW3_4 / period_0) * 360) -360
let phase4_5 = ((SKEW4_5 / period_0) * 360) -360
let phase5_0 = ((SKEW5_0 / period_0) * 360) -360

let freq0 = 1/T0
let freq5 = 1/T5

meas tran PW0 TRIG v(v0) VAL=0.6 RISE=3 TARG v(v0) VAL=0.6 FALL=4
meas tran PW1 TRIG v(v1) VAL=0.6 RISE=3 TARG v(v1) VAL=0.6 FALL=4
meas tran PW2 TRIG v(v2) VAL=0.6 RISE=3 TARG v(v2) VAL=0.6 FALL=4
meas tran PW3 TRIG v(v3) VAL=0.6 RISE=3 TARG v(v3) VAL=0.6 FALL=4
meas tran PW4 TRIG v(v4) VAL=0.6 RISE=3 TARG v(v4) VAL=0.6 FALL=4
meas tran PW5 TRIG v(v5) VAL=0.6 RISE=3 TARG v(v5) VAL=0.6 FALL=4

let Duty0 = PW0 / period_0
let Duty1 = PW1 / period_1
let Duty2 = PW2 / period_2
let Duty3 = PW3 / period_3
let Duty4 = PW4 / period_4
let Duty5 = PW5 / period_5

meas tran SKEW0_90 TRIG v(v0_) VAL=0.6 RISE=3 TARG v(v90) VAL=0.6 RISE=3
meas tran SKEW90_180 TRIG v(v90) VAL=0.6 RISE=3 TARG v(v180) VAL=0.6 RISE=3
meas tran SKEW180_270 TRIG v(v180) VAL=0.6 RISE=3 TARG v(v270) VAL=0.6 RISE=4
meas tran SKEW270_0 TRIG v(v270) VAL=0.6 RISE=3 TARG v(v0_) VAL=0.6 RISE=3

meas tran T0_ TRIG v(v0_) VAL=0.6 RISE=3 TARG v(v0_) VAL=0.6 RISE=4
meas tran T90 TRIG v(v90) VAL=0.6 RISE=3 TARG v(v90) VAL=0.6 RISE=4
meas tran T180 TRIG v(v180) VAL=0.6 RISE=3 TARG v(v180) VAL=0.6 RISE=4
meas tran T270 TRIG v(v270) VAL=0.6 RISE=3 TARG v(v270) VAL=0.6 RISE=4

let period_0_ = T0_
let period_90 = T90
let period_180 = T180
let period_270 = T270

let phase0_90 = ((SKEW0_90 / period_0_) * 360)
let phase90_180 = ((SKEW90_180 / period_90) * 360)
let phase180_270 = ((SKEW180_270 / period_180) * 360)
let phase270_0 = ((SKEW270_0 / period_270) * 360)

meas tran PW0_ TRIG v(v0_) VAL=0.6 RISE=3 TARG v(v0_) VAL=0.6 FALL=4
meas tran PW90 TRIG v(v90) VAL=0.6 RISE=3 TARG v(v90) VAL=0.6 FALL=4
meas tran PW180 TRIG v(v180) VAL=0.6 RISE=3 TARG v(v180) VAL=0.6 FALL=4
meas tran PW270 TRIG v(v270) VAL=0.6 RISE=3 TARG v(v270) VAL=0.6 FALL=4

let Duty0_ = PW0_ / period_0_
let Duty90 = PW90 / period_90
let Duty180 = PW180 / period_180
let Duty270 = PW270 / period_270

print phase0_1 phase1_2 phase2_3 phase3_4 phase4_5 phase5_0 freq0 freq5 Duty0 Duty1 Duty2 Duty3 Duty4 Duty5 phase0_90 phase90_180 phase180_270 phase270_0 Duty0_ Duty90 Duty180 Duty270

.endc

**** end user architecture code
**.ends

* expanding   symbol:  2to4_rosc.sym # of pins=9
** sym_path: /foss/designs/PhaseInterpolator/2to4/2to4_rosc.sym
** sch_path: /foss/designs/PhaseInterpolator/2to4/2to4_rosc.sch
.subckt 2to4_rosc CTRL Ph0 Ph3 Ph2 Ph5 Ph4 Ph1 VSS VDD
*.iopin VDD
*.iopin VSS
*.ipin CTRL
*.opin Ph0
*.opin Ph2
*.opin Ph5
*.opin Ph1
*.opin Ph4
*.opin Ph3
x1 VDD net1 net2 CTRL net6 net5 VSS 2to4_psdiff
x2 VDD net3 net4 CTRL net2 net1 VSS 2to4_psdiff
x3 VDD net5 net6 CTRL net4 net3 VSS 2to4_psdiff
x4 CTRL Ph0 Ph3 VDD 2to4_decap
x5 CTRL Ph2 Ph5 VDD 2to4_decap
x6 CTRL Ph1 Ph4 VDD 2to4_decap
x7 VDD Ph1 net2 VSS buff_d8
x8 VDD Ph4 net1 VSS buff_d8
x9 VDD Ph5 net4 VSS buff_d8
x10 VDD Ph2 net3 VSS buff_d8
x11 VDD Ph3 net6 VSS buff_d8
x12 VDD Ph0 net5 VSS buff_d8
x13 VDD Ph0 Ph3 VSS inv_d2
x14 VDD Ph3 Ph0 VSS inv_d2
x15 VDD Ph4 Ph1 VSS inv_d2
x16 VDD Ph1 Ph4 VSS inv_d2
x17 VDD Ph2 Ph5 VSS inv_d2
x18 VDD Ph5 Ph2 VSS inv_d2
.ends

* expanding   symbol:  /foss/designs/PhaseInterpolator/Custom_std_cells/inv_PI_d2.sym # of pins=4
** sym_path: /foss/designs/PhaseInterpolator/Custom_std_cells/inv_PI_d2.sym
** sch_path: /foss/designs/PhaseInterpolator/Custom_std_cells/inv_PI_d2.sch
.subckt inv_PI_d2 VDD VOUT VIN VSS
*.ipin VIN
*.opin VOUT
*.iopin VDD
*.iopin VSS
x1[1] VDD VOUT VIN VSS inv_PI
x1[0] VDD VOUT VIN VSS inv_PI
.ends

* expanding   symbol:  2to4_psdiff.sym # of pins=7
** sym_path: /foss/designs/PhaseInterpolator/2to4/2to4_psdiff.sym
** sch_path: /foss/designs/PhaseInterpolator/2to4/2to4_psdiff.sch
.subckt 2to4_psdiff VDD VOUTDN VOUTDP CTRL CLKN CLKP VSS
*.iopin VSS
*.ipin CLKP
*.ipin CLKN
*.iopin VDD
*.ipin CTRL
*.opin VOUTDN
*.opin VOUTDP
XM1 net1 CLKP VSS VSS sg13_lv_nmos w=0.15u l=0.13u ng=1 m=30
XM2 net2 CLKN VSS VSS sg13_lv_nmos w=0.15u l=0.13u ng=1 m=30
XM3 net3 CTRL net1 VSS sg13_lv_nmos w=0.15u l=0.13u ng=1 m=2
XM4 net4 CTRL net2 VSS sg13_lv_nmos w=0.15u l=0.13u ng=1 m=2
XM6 net2 net3 VDD VDD sg13_lv_pmos w=0.15u l=0.13u ng=1 m=12
XM5 net1 net4 VDD VDD sg13_lv_pmos w=0.15u l=0.13u ng=1 m=12
XM7 net1 VSS VDD VDD sg13_lv_pmos w=0.15u l=0.13u ng=1 m=20
XM8 net2 VSS VDD VDD sg13_lv_pmos w=0.15u l=0.13u ng=1 m=20
x1 VDD VOUTDP net2 VSS buff_d8
x2 VDD VOUTDN net1 VSS buff_d8
.ends

* expanding   symbol:  2to4_decap.sym # of pins=4
** sym_path: /foss/designs/PhaseInterpolator/2to4/2to4_decap.sym
** sch_path: /foss/designs/PhaseInterpolator/2to4/2to4_decap.sch
.subckt 2to4_decap CTRL VOUTDN VOUTDP VDD
*.ipin CTRL
*.ipin VDD
*.ipin VOUTDN
*.ipin VOUTDP
XM10 CTRL VOUTDP CTRL VDD sg13_lv_pmos w=1u l=0.13u ng=1 m=32
XM9 CTRL VOUTDN CTRL VDD sg13_lv_pmos w=1u l=0.13u ng=1 m=32
.ends

* expanding   symbol:  /foss/designs/PhaseInterpolator/Custom_std_cells/buff_d8.sym # of pins=4
** sym_path: /foss/designs/PhaseInterpolator/Custom_std_cells/buff_d8.sym
** sch_path: /foss/designs/PhaseInterpolator/Custom_std_cells/buff_d8.sch
.subckt buff_d8 VDD VOUT VIN VSS
*.ipin VIN
*.opin VOUT
*.iopin VDD
*.iopin VSS
x7 VDD net1 VIN VSS inv
x8 VDD net2 net1 VSS inv_d2
x9 VDD net3 net2 VSS inv_d4
x10 VDD VOUT net3 VSS inv_d8
.ends

* expanding   symbol:  /foss/designs/PhaseInterpolator/Custom_std_cells/inv_d2.sym # of pins=4
** sym_path: /foss/designs/PhaseInterpolator/Custom_std_cells/inv_d2.sym
** sch_path: /foss/designs/PhaseInterpolator/Custom_std_cells/inv_d2.sch
.subckt inv_d2 VDD VOUT VIN VSS
*.ipin VIN
*.opin VOUT
*.iopin VDD
*.iopin VSS
x1[1] VDD VOUT VIN VSS inv
x1[0] VDD VOUT VIN VSS inv
.ends

* expanding   symbol:  /foss/designs/PhaseInterpolator/Custom_std_cells/inv_PI.sym # of pins=4
** sym_path: /foss/designs/PhaseInterpolator/Custom_std_cells/inv_PI.sym
** sch_path: /foss/designs/PhaseInterpolator/Custom_std_cells/inv_PI.sch
.subckt inv_PI VDD VOUT VIN VSS
*.iopin VDD
*.iopin VSS
*.opin VOUT
*.ipin VIN
XM2 VOUT VIN VDD VDD sg13_lv_pmos w=0.45u l=0.13u ng=3 m=1
XM1 VOUT VIN VSS VSS sg13_lv_nmos w=0.3u l=0.13u ng=2 m=1
.ends

* expanding   symbol:  /foss/designs/PhaseInterpolator/Custom_std_cells/inv.sym # of pins=4
** sym_path: /foss/designs/PhaseInterpolator/Custom_std_cells/inv.sym
** sch_path: /foss/designs/PhaseInterpolator/Custom_std_cells/inv.sch
.subckt inv VDD VOUT VIN VSS
*.iopin VDD
*.iopin VSS
*.opin VOUT
*.ipin VIN
XM2 VOUT VIN VDD VDD sg13_lv_pmos w=0.15u l=0.13u ng=1 m=1
XM1 VOUT VIN VSS VSS sg13_lv_nmos w=0.15u l=0.13u ng=1 m=1
.ends

* expanding   symbol:  /foss/designs/PhaseInterpolator/Custom_std_cells/inv_d4.sym # of pins=4
** sym_path: /foss/designs/PhaseInterpolator/Custom_std_cells/inv_d4.sym
** sch_path: /foss/designs/PhaseInterpolator/Custom_std_cells/inv_d4.sch
.subckt inv_d4 VDD VOUT VIN VSS
*.ipin VIN
*.opin VOUT
*.iopin VDD
*.iopin VSS
x1[1] VDD VOUT VIN VSS inv_d2
x1[0] VDD VOUT VIN VSS inv_d2
.ends

* expanding   symbol:  /foss/designs/PhaseInterpolator/Custom_std_cells/inv_d8.sym # of pins=4
** sym_path: /foss/designs/PhaseInterpolator/Custom_std_cells/inv_d8.sym
** sch_path: /foss/designs/PhaseInterpolator/Custom_std_cells/inv_d8.sch
.subckt inv_d8 VDD VOUT VIN VSS
*.ipin VIN
*.opin VOUT
*.iopin VDD
*.iopin VSS
x1[1] VDD VOUT VIN VSS inv_d4
x1[0] VDD VOUT VIN VSS inv_d4
.ends

.GLOBAL GND
.end
