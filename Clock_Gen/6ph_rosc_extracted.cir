* Extracted by KLayout with SG13G2 LVS runset on : 06/03/2026 05:14

.SUBCKT 6ph_rosc VSS VDD CTRL PH1 PH4 PH2 PH5 PH0 PH3
X$1 PH1 PH4 VSS VDD flywheel
X$2 PH0 PH3 VSS VDD flywheel
X$3 PH2 PH5 VSS VDD flywheel
X$4 VSS \$2 \$29 CTRL \$25 VDD \$32 psdiff
X$5 VSS \$25 \$24 CTRL \$15 VDD \$29 psdiff
X$6 VSS \$15 \$32 CTRL \$2 VDD \$24 psdiff
X$7 \$I42 VSS VDD \$I17 PH2 buff_d8
X$8 CTRL PH2 VDD PH5 decap
X$9 \$I41 VSS VDD \$29 PH1 buff_d8
X$10 CTRL PH1 VDD PH4 decap
X$11 CTRL PH0 VDD PH3 decap
X$12 \$I43 VSS VDD \$I18 PH0 buff_d8
X$13 \$25 VSS VDD \$I13 PH4 buff_d8
X$14 \$2 VSS VDD \$I14 PH5 buff_d8
X$15 \$15 VSS VDD \$I15 PH3 buff_d8
.ENDS 6ph_rosc

.SUBCKT flywheel PH1 PH0 VSS VDD
X$1 VSS PH1 PH0 VDD inv_d2
X$2 VSS PH0 PH1 VDD inv_d2
.ENDS flywheel

.SUBCKT decap CTRL VOUTDN VDD VOUTDP
M$1 CTRL VOUTDN CTRL VDD sg13_lv_pmos L=0.13u W=32u AS=6.68p AD=6.08p PS=49.36u
+ PD=44.16u
M$9 CTRL VOUTDP CTRL VDD sg13_lv_pmos L=0.13u W=32u AS=6.08p AD=6.68p PS=44.16u
+ PD=49.36u
.ENDS decap

.SUBCKT psdiff VSS VOUTDP CLKP CTRL CLKN VDD VOUTDN
X$1 \$I714 VSS VDD \$2 VOUTDP buff_d8
X$4 \$I713 VSS VDD \$7 VOUTDN buff_d8
M$1 VSS CLKP \$7 VSS sg13_lv_nmos L=0.13u W=4.5u AS=1.8p AD=1.665p PS=24u
+ PD=22.2u
M$11 VSS CLKN \$2 VSS sg13_lv_nmos L=0.13u W=4.5u AS=1.665p AD=1.8p PS=22.2u
+ PD=24u
M$61 VDD VSS \$2 VDD sg13_lv_pmos L=0.13u W=3u AS=1.2p AD=1.11p PS=16u PD=14.8u
M$71 VDD VSS \$7 VDD sg13_lv_pmos L=0.13u W=3u AS=1.11p AD=1.2p PS=14.8u PD=16u
M$101 VDD \$58 \$2 VDD sg13_lv_pmos L=0.13u W=1.5u AS=0.6p AD=0.555p PS=8u
+ PD=7.4u
M$111 VDD \$64 \$7 VDD sg13_lv_pmos L=0.13u W=1.5u AS=0.555p AD=0.6p PS=7.4u
+ PD=8u
M$121 \$7 CTRL \$58 VSS sg13_lv_nmos L=0.13u W=0.3u AS=0.156p AD=0.156p
+ PS=2.08u PD=2.08u
M$123 \$2 CTRL \$64 VSS sg13_lv_nmos L=0.13u W=0.3u AS=0.156p AD=0.156p
+ PS=2.08u PD=2.08u
.ENDS psdiff

.SUBCKT buff_d8 \$1 VSS VDD VIN VOUT
X$1 VSS \$2 \$1 VDD inv_d2
X$3 VSS \$2 \$3 VDD inv_d4
X$4 VOUT VSS \$3 VDD inv_d8
M$1 VSS VIN \$1 VSS sg13_lv_nmos L=0.13u W=0.15u AS=0.1005p AD=0.1005p PS=1.34u
+ PD=1.34u
M$2 VDD VIN \$1 VDD sg13_lv_pmos L=0.13u W=0.15u AS=0.1005p AD=0.1005p PS=1.34u
+ PD=1.34u
.ENDS buff_d8

.SUBCKT inv_d8 VOUT VSS VIN VDD
X$1 VSS VIN VOUT VDD inv_d4
X$2 VSS VIN VOUT VDD inv_d4
.ENDS inv_d8

.SUBCKT inv_d4 VSS VIN VOUT VDD
X$1 VSS VOUT VIN VDD inv_d2
X$2 VSS VOUT VIN VDD inv_d2
.ENDS inv_d4

.SUBCKT inv_d2 VSS VOUT VIN VDD
M$1 VSS VIN VOUT VSS sg13_lv_nmos L=0.13u W=0.3u AS=0.156p AD=0.156p PS=2.08u
+ PD=2.08u
M$3 VDD VIN VOUT VDD sg13_lv_pmos L=0.13u W=0.3u AS=0.156p AD=0.156p PS=2.08u
+ PD=2.08u
.ENDS inv_d2
