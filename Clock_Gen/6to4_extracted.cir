* Extracted by KLayout with SG13G2 LVS runset on : 23/03/2026 15:28

.SUBCKT 6to4 VSS VIN|VOUT PH270|VOUT PH1|V5|VIN VIN VIN|VOUT$1 VIN|VOUT$2
+ VIN|VOUT$3 VIN|VOUT$4 VDD PH1|VIN|VOUT PH0|VIN|VOUT PH1|PHOUT|VIN|VOUT
+ PH0|V4|VIN VIN|VOUT$5 PH180|VOUT VIN$1 VIN|VOUT$6 VIN|VOUT$7 VIN|VOUT$8
+ V3|VIN VIN|VOUT$9 PH90|VOUT VIN|VOUT$10 PH1|V2|VIN VIN$2 VIN|VOUT$11
+ VIN|VOUT$12 VIN|VOUT$13 VIN|VOUT$14 PH0|PHOUT|VIN|VOUT PH0|V1|VIN VIN|VOUT$15
+ PH0|VOUT VIN$3 VIN|VOUT$16 VIN|VOUT$17 VIN|VOUT$18 V0|VIN VIN|VOUT$19
M$1 VSS VIN|VOUT PH270|VOUT VSS sg13_lv_nmos L=0.13u W=9.6u AS=4.992p AD=4.992p
+ PS=66.56u PD=66.56u
M$33 VSS PH0|VIN|VOUT PH1|VIN|VOUT VSS sg13_lv_nmos L=0.13u W=0.6u AS=0.312p
+ AD=0.312p PS=4.16u PD=4.16u
M$37 VSS PH1|VIN|VOUT PH0|VIN|VOUT VSS sg13_lv_nmos L=0.13u W=0.3u AS=0.156p
+ AD=0.156p PS=2.08u PD=2.08u
M$39 VSS PH1|V5|VIN VIN|VOUT$4 VSS sg13_lv_nmos L=0.13u W=0.6u AS=0.312p
+ AD=0.312p PS=4.16u PD=4.16u
M$43 VSS VIN VIN|VOUT$1 VSS sg13_lv_nmos L=0.13u W=0.6u AS=0.312p AD=0.312p
+ PS=4.16u PD=4.16u
M$47 VSS VIN|VOUT$1 PH1|PHOUT|VIN|VOUT VSS sg13_lv_nmos L=0.13u W=1.2u
+ AS=0.624p AD=0.624p PS=8.32u PD=8.32u
M$55 VSS VIN|VOUT$2 VIN|VOUT$3 VSS sg13_lv_nmos L=0.13u W=4.8u AS=2.496p
+ AD=2.496p PS=33.28u PD=33.28u
M$71 VSS VIN|VOUT$3 VIN|VOUT VSS sg13_lv_nmos L=0.13u W=4.8u AS=2.496p
+ AD=2.496p PS=33.28u PD=33.28u
M$103 VSS VIN|VOUT$4 PH1|PHOUT|VIN|VOUT VSS sg13_lv_nmos L=0.13u W=0.6u
+ AS=0.312p AD=0.312p PS=4.16u PD=4.16u
M$105 VSS PH0|V4|VIN VIN|VOUT$4 VSS sg13_lv_nmos L=0.13u W=0.6u AS=0.312p
+ AD=0.312p PS=4.16u PD=4.16u
M$111 VSS PH1|PHOUT|VIN|VOUT VIN|VOUT$2 VSS sg13_lv_nmos L=0.13u W=2.4u
+ AS=1.248p AD=1.248p PS=16.64u PD=16.64u
M$159 VSS VIN|VOUT$5 PH180|VOUT VSS sg13_lv_nmos L=0.13u W=9.6u AS=4.992p
+ AD=4.992p PS=66.56u PD=66.56u
M$207 VSS VIN$1 VIN|VOUT$6 VSS sg13_lv_nmos L=0.13u W=0.6u AS=0.312p AD=0.312p
+ PS=4.16u PD=4.16u
M$211 VSS VIN|VOUT$6 PH1|VIN|VOUT VSS sg13_lv_nmos L=0.13u W=1.2u AS=0.624p
+ AD=0.624p PS=8.32u PD=8.32u
M$219 VSS VIN|VOUT$7 VIN|VOUT$8 VSS sg13_lv_nmos L=0.13u W=4.8u AS=2.496p
+ AD=2.496p PS=33.28u PD=33.28u
M$235 VSS VIN|VOUT$8 VIN|VOUT$5 VSS sg13_lv_nmos L=0.13u W=4.8u AS=2.496p
+ AD=2.496p PS=33.28u PD=33.28u
M$267 VSS V3|VIN VIN|VOUT$9 VSS sg13_lv_nmos L=0.13u W=0.6u AS=0.312p AD=0.312p
+ PS=4.16u PD=4.16u
M$271 VSS VIN|VOUT$9 PH1|VIN|VOUT VSS sg13_lv_nmos L=0.13u W=0.6u AS=0.312p
+ AD=0.312p PS=4.16u PD=4.16u
M$275 VSS PH1|VIN|VOUT VIN|VOUT$7 VSS sg13_lv_nmos L=0.13u W=2.4u AS=1.248p
+ AD=1.248p PS=16.64u PD=16.64u
M$325 VSS VIN|VOUT$10 PH90|VOUT VSS sg13_lv_nmos L=0.13u W=9.6u AS=4.992p
+ AD=4.992p PS=66.56u PD=66.56u
M$371 VSS PH0|PHOUT|VIN|VOUT PH1|PHOUT|VIN|VOUT VSS sg13_lv_nmos L=0.13u W=0.6u
+ AS=0.312p AD=0.312p PS=4.16u PD=4.16u
M$375 VSS PH1|PHOUT|VIN|VOUT PH0|PHOUT|VIN|VOUT VSS sg13_lv_nmos L=0.13u W=0.3u
+ AS=0.156p AD=0.156p PS=2.08u PD=2.08u
M$377 VSS PH1|V2|VIN VIN|VOUT$14 VSS sg13_lv_nmos L=0.13u W=0.6u AS=0.312p
+ AD=0.312p PS=4.16u PD=4.16u
M$381 VSS VIN$2 VIN|VOUT$11 VSS sg13_lv_nmos L=0.13u W=0.6u AS=0.312p AD=0.312p
+ PS=4.16u PD=4.16u
M$385 VSS VIN|VOUT$11 PH0|PHOUT|VIN|VOUT VSS sg13_lv_nmos L=0.13u W=1.2u
+ AS=0.624p AD=0.624p PS=8.32u PD=8.32u
M$393 VSS VIN|VOUT$12 VIN|VOUT$13 VSS sg13_lv_nmos L=0.13u W=4.8u AS=2.496p
+ AD=2.496p PS=33.28u PD=33.28u
M$409 VSS VIN|VOUT$13 VIN|VOUT$10 VSS sg13_lv_nmos L=0.13u W=4.8u AS=2.496p
+ AD=2.496p PS=33.28u PD=33.28u
M$441 VSS VIN|VOUT$14 PH0|PHOUT|VIN|VOUT VSS sg13_lv_nmos L=0.13u W=0.6u
+ AS=0.312p AD=0.312p PS=4.16u PD=4.16u
M$443 VSS PH0|V1|VIN VIN|VOUT$14 VSS sg13_lv_nmos L=0.13u W=0.6u AS=0.312p
+ AD=0.312p PS=4.16u PD=4.16u
M$449 VSS PH0|PHOUT|VIN|VOUT VIN|VOUT$12 VSS sg13_lv_nmos L=0.13u W=2.4u
+ AS=1.248p AD=1.248p PS=16.64u PD=16.64u
M$499 VSS VIN|VOUT$15 PH0|VOUT VSS sg13_lv_nmos L=0.13u W=9.6u AS=4.992p
+ AD=4.992p PS=66.56u PD=66.56u
M$545 VSS VIN$3 VIN|VOUT$16 VSS sg13_lv_nmos L=0.13u W=0.6u AS=0.312p AD=0.312p
+ PS=4.16u PD=4.16u
M$549 VSS VIN|VOUT$16 PH0|VIN|VOUT VSS sg13_lv_nmos L=0.13u W=1.2u AS=0.624p
+ AD=0.624p PS=8.32u PD=8.32u
M$557 VSS VIN|VOUT$17 VIN|VOUT$18 VSS sg13_lv_nmos L=0.13u W=4.8u AS=2.496p
+ AD=2.496p PS=33.28u PD=33.28u
M$573 VSS VIN|VOUT$18 VIN|VOUT$15 VSS sg13_lv_nmos L=0.13u W=4.8u AS=2.496p
+ AD=2.496p PS=33.28u PD=33.28u
M$605 VSS V0|VIN VIN|VOUT$19 VSS sg13_lv_nmos L=0.13u W=0.6u AS=0.312p
+ AD=0.312p PS=4.16u PD=4.16u
M$609 VSS VIN|VOUT$19 PH0|VIN|VOUT VSS sg13_lv_nmos L=0.13u W=0.6u AS=0.312p
+ AD=0.312p PS=4.16u PD=4.16u
M$613 VSS PH0|VIN|VOUT VIN|VOUT$17 VSS sg13_lv_nmos L=0.13u W=2.4u AS=1.248p
+ AD=1.248p PS=16.64u PD=16.64u
M$677 VDD VIN|VOUT PH270|VOUT VDD sg13_lv_pmos L=0.13u W=14.4u AS=6.768p
+ AD=6.768p PS=90.24u PD=90.24u
M$725 VDD PH1|V5|VIN VIN|VOUT$4 VDD sg13_lv_pmos L=0.13u W=0.9u AS=0.423p
+ AD=0.423p PS=5.64u PD=5.64u
M$731 VDD VIN VIN|VOUT$1 VDD sg13_lv_pmos L=0.13u W=0.9u AS=0.423p AD=0.423p
+ PS=5.64u PD=5.64u
M$737 VDD VIN|VOUT$1 PH1|PHOUT|VIN|VOUT VDD sg13_lv_pmos L=0.13u W=1.8u
+ AS=0.846p AD=0.846p PS=11.28u PD=11.28u
M$749 VDD VIN|VOUT$2 VIN|VOUT$3 VDD sg13_lv_pmos L=0.13u W=7.2u AS=3.384p
+ AD=3.384p PS=45.12u PD=45.12u
M$773 VDD VIN|VOUT$3 VIN|VOUT VDD sg13_lv_pmos L=0.13u W=7.2u AS=3.384p
+ AD=3.384p PS=45.12u PD=45.12u
M$821 VDD PH0|VIN|VOUT PH1|VIN|VOUT VDD sg13_lv_pmos L=0.13u W=0.6u AS=0.312p
+ AD=0.312p PS=4.16u PD=4.16u
M$825 VDD PH1|VIN|VOUT PH0|VIN|VOUT VDD sg13_lv_pmos L=0.13u W=0.3u AS=0.156p
+ AD=0.156p PS=2.08u PD=2.08u
M$827 VDD VIN|VOUT$4 PH1|PHOUT|VIN|VOUT VDD sg13_lv_pmos L=0.13u W=0.9u
+ AS=0.423p AD=0.423p PS=5.64u PD=5.64u
M$833 VDD PH1|PHOUT|VIN|VOUT VIN|VOUT$2 VDD sg13_lv_pmos L=0.13u W=3.6u
+ AS=1.692p AD=1.692p PS=22.56u PD=22.56u
M$929 VDD PH0|V4|VIN VIN|VOUT$4 VDD sg13_lv_pmos L=0.13u W=0.9u AS=0.423p
+ AD=0.423p PS=5.64u PD=5.64u
M$935 VDD VIN|VOUT$5 PH180|VOUT VDD sg13_lv_pmos L=0.13u W=14.4u AS=6.768p
+ AD=6.768p PS=90.24u PD=90.24u
M$983 VDD VIN$1 VIN|VOUT$6 VDD sg13_lv_pmos L=0.13u W=0.9u AS=0.423p AD=0.423p
+ PS=5.64u PD=5.64u
M$989 VDD VIN|VOUT$6 PH1|VIN|VOUT VDD sg13_lv_pmos L=0.13u W=1.8u AS=0.846p
+ AD=0.846p PS=11.28u PD=11.28u
M$1001 VDD VIN|VOUT$7 VIN|VOUT$8 VDD sg13_lv_pmos L=0.13u W=7.2u AS=3.384p
+ AD=3.384p PS=45.12u PD=45.12u
M$1025 VDD VIN|VOUT$8 VIN|VOUT$5 VDD sg13_lv_pmos L=0.13u W=7.2u AS=3.384p
+ AD=3.384p PS=45.12u PD=45.12u
M$1073 VDD V3|VIN VIN|VOUT$9 VDD sg13_lv_pmos L=0.13u W=0.9u AS=0.423p
+ AD=0.423p PS=5.64u PD=5.64u
M$1079 VDD VIN|VOUT$9 PH1|VIN|VOUT VDD sg13_lv_pmos L=0.13u W=0.9u AS=0.423p
+ AD=0.423p PS=5.64u PD=5.64u
M$1085 VDD PH1|VIN|VOUT VIN|VOUT$7 VDD sg13_lv_pmos L=0.13u W=3.6u AS=1.692p
+ AD=1.692p PS=22.56u PD=22.56u
M$1160 VDD VIN|VOUT$10 PH90|VOUT VDD sg13_lv_pmos L=0.13u W=14.4u AS=6.768p
+ AD=6.768p PS=90.24u PD=90.24u
M$1229 VDD PH1|V2|VIN VIN|VOUT$14 VDD sg13_lv_pmos L=0.13u W=0.9u AS=0.423p
+ AD=0.423p PS=5.64u PD=5.64u
M$1235 VDD VIN$2 VIN|VOUT$11 VDD sg13_lv_pmos L=0.13u W=0.9u AS=0.423p
+ AD=0.423p PS=5.64u PD=5.64u
M$1241 VDD VIN|VOUT$11 PH0|PHOUT|VIN|VOUT VDD sg13_lv_pmos L=0.13u W=1.8u
+ AS=0.846p AD=0.846p PS=11.28u PD=11.28u
M$1253 VDD VIN|VOUT$12 VIN|VOUT$13 VDD sg13_lv_pmos L=0.13u W=7.2u AS=3.384p
+ AD=3.384p PS=45.12u PD=45.12u
M$1277 VDD VIN|VOUT$13 VIN|VOUT$10 VDD sg13_lv_pmos L=0.13u W=7.2u AS=3.384p
+ AD=3.384p PS=45.12u PD=45.12u
M$1325 VDD PH0|PHOUT|VIN|VOUT PH1|PHOUT|VIN|VOUT VDD sg13_lv_pmos L=0.13u
+ W=0.6u AS=0.312p AD=0.312p PS=4.16u PD=4.16u
M$1329 VDD PH1|PHOUT|VIN|VOUT PH0|PHOUT|VIN|VOUT VDD sg13_lv_pmos L=0.13u
+ W=0.3u AS=0.156p AD=0.156p PS=2.08u PD=2.08u
M$1331 VDD VIN|VOUT$14 PH0|PHOUT|VIN|VOUT VDD sg13_lv_pmos L=0.13u W=0.9u
+ AS=0.423p AD=0.423p PS=5.64u PD=5.64u
M$1337 VDD PH0|PHOUT|VIN|VOUT VIN|VOUT$12 VDD sg13_lv_pmos L=0.13u W=3.6u
+ AS=1.692p AD=1.692p PS=22.56u PD=22.56u
M$1433 VDD PH0|V1|VIN VIN|VOUT$14 VDD sg13_lv_pmos L=0.13u W=0.9u AS=0.423p
+ AD=0.423p PS=5.64u PD=5.64u
M$1439 VDD VIN|VOUT$15 PH0|VOUT VDD sg13_lv_pmos L=0.13u W=14.4u AS=6.768p
+ AD=6.768p PS=90.24u PD=90.24u
M$1487 VDD VIN$3 VIN|VOUT$16 VDD sg13_lv_pmos L=0.13u W=0.9u AS=0.423p
+ AD=0.423p PS=5.64u PD=5.64u
M$1493 VDD VIN|VOUT$16 PH0|VIN|VOUT VDD sg13_lv_pmos L=0.13u W=1.8u AS=0.846p
+ AD=0.846p PS=11.28u PD=11.28u
M$1505 VDD VIN|VOUT$17 VIN|VOUT$18 VDD sg13_lv_pmos L=0.13u W=7.2u AS=3.384p
+ AD=3.384p PS=45.12u PD=45.12u
M$1529 VDD VIN|VOUT$18 VIN|VOUT$15 VDD sg13_lv_pmos L=0.13u W=7.2u AS=3.384p
+ AD=3.384p PS=45.12u PD=45.12u
M$1577 VDD V0|VIN VIN|VOUT$19 VDD sg13_lv_pmos L=0.13u W=0.9u AS=0.423p
+ AD=0.423p PS=5.64u PD=5.64u
M$1583 VDD VIN|VOUT$19 PH0|VIN|VOUT VDD sg13_lv_pmos L=0.13u W=0.9u AS=0.423p
+ AD=0.423p PS=5.64u PD=5.64u
M$1589 VDD PH0|VIN|VOUT VIN|VOUT$17 VDD sg13_lv_pmos L=0.13u W=3.6u AS=1.692p
+ AD=1.692p PS=22.56u PD=22.56u
.ENDS 6to4
