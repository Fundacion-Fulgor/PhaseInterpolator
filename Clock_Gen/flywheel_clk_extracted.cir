* Extracted by KLayout with SG13G2 LVS runset on : 04/03/2026 01:28

.SUBCKT flywheel_clk PH0 VSS PH1 VDD
X$1 PH1 VSS VDD PH0 inv_d4
X$2 PH1 VSS VDD PH0 inv_d2
.ENDS flywheel_clk

.SUBCKT inv_d4 VOUT VSS VDD VIN
X$1 VIN VSS VDD VOUT inv_d2
X$2 VIN VSS VDD VOUT inv_d2
.ENDS inv_d4

.SUBCKT inv_d2 VIN VSS VDD VOUT
M$1 VSS VIN VOUT VSS sg13_lv_nmos L=0.13u W=0.3u AS=0.156p AD=0.156p PS=2.08u
+ PD=2.08u
M$3 VDD VIN VOUT VDD sg13_lv_pmos L=0.13u W=0.3u AS=0.156p AD=0.156p PS=2.08u
+ PD=2.08u
.ENDS inv_d2
