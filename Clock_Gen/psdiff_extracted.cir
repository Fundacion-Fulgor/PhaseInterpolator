* Extracted by KLayout with SG13G2 LVS runset on : 05/03/2026 10:15

.SUBCKT psdiff VSS VOUTDP CLKP CLKN VDD VOUTDN
X$1 VSS VDD \$3 VOUTDP buff_d8
X$4 VSS VDD \$3 VOUTDN buff_d8
M$1 VSS CLKP \$3 VSS sg13_lv_nmos L=0.13u W=4.5u AS=1.8p AD=1.665p PS=24u
+ PD=22.2u
M$11 VSS CLKN \$3 VSS sg13_lv_nmos L=0.13u W=4.5u AS=1.665p AD=1.8p PS=22.2u
+ PD=24u
M$61 VDD \$119 \$3 VDD sg13_lv_pmos L=0.13u W=6u AS=2.31p AD=2.31p PS=30.8u
+ PD=30.8u
M$101 VDD \$91 \$3 VDD sg13_lv_pmos L=0.13u W=1.5u AS=0.6p AD=0.555p PS=8u
+ PD=7.4u
M$111 VDD \$94 \$3 VDD sg13_lv_pmos L=0.13u W=1.5u AS=0.555p AD=0.6p PS=7.4u
+ PD=8u
M$121 \$3 \$118 \$91 VSS sg13_lv_nmos L=0.13u W=0.3u AS=0.156p AD=0.156p
+ PS=2.08u PD=2.08u
M$123 \$3 \$118 \$94 VSS sg13_lv_nmos L=0.13u W=0.3u AS=0.156p AD=0.156p
+ PS=2.08u PD=2.08u
.ENDS psdiff

.SUBCKT buff_d8 VSS VDD VIN VOUT
X$1 \$1 VSS VDD \$2 inv_d2
X$3 \$3 VSS \$2 VDD inv_d4
X$4 VOUT VSS \$3 VDD inv_d8
M$1 VSS VIN \$1 VSS sg13_lv_nmos L=0.13u W=0.15u AS=0.1005p AD=0.1005p PS=1.34u
+ PD=1.34u
M$2 VDD VIN \$1 VDD sg13_lv_pmos L=0.13u W=0.15u AS=0.1005p AD=0.1005p PS=1.34u
+ PD=1.34u
.ENDS buff_d8

.SUBCKT inv_d8 VOUT VSS VIN VDD
X$1 VOUT VSS VIN VDD inv_d4
X$2 VOUT VSS VIN VDD inv_d4
.ENDS inv_d8

.SUBCKT inv_d4 VOUT VSS VIN VDD
X$1 VIN VSS VDD VOUT inv_d2
X$2 VIN VSS VDD VOUT inv_d2
.ENDS inv_d4

.SUBCKT inv_d2 VIN VSS VDD VOUT
M$1 VSS VIN VOUT VSS sg13_lv_nmos L=0.13u W=0.3u AS=0.156p AD=0.156p PS=2.08u
+ PD=2.08u
M$3 VDD VIN VOUT VDD sg13_lv_pmos L=0.13u W=0.3u AS=0.156p AD=0.156p PS=2.08u
+ PD=2.08u
.ENDS inv_d2
