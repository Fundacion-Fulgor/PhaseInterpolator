* Extracted by KLayout with SG13G2 LVS runset on : 01/03/2026 22:09

.SUBCKT flywheel PH1 PH0 VSS VDD
X$1 PH1 VSS VDD PH0 inv_d2
X$2 PH0 VSS VDD PH1 inv_d2
.ENDS flywheel

.SUBCKT inv_d2 VIN VSS VDD VOUT
M$1 VSS VIN VOUT VSS sg13_lv_nmos L=0.13u W=0.3u AS=0.156p AD=0.156p PS=2.08u
+ PD=2.08u
M$3 VDD VIN VOUT VDD sg13_lv_pmos L=0.13u W=0.3u AS=0.156p AD=0.156p PS=2.08u
+ PD=2.08u
.ENDS inv_d2
