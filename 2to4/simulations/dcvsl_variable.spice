** sch_path: /foss/designs/PhaseInterpolator/2to4/dcvsl_variable.sch
**.subckt dcvsl_variable VDD VOUTN VOUTP CTRL CLKN CLKP VSS
*.iopin VSS
*.ipin CLKP
*.opin VOUTP
*.ipin CLKN
*.iopin VDD
*.opin VOUTN
*.ipin CTRL
XM1 VOUTN CLKP VSS VSS sg13_lv_nmos w=0.15u l=0.13u ng=1 m=30
XM2 VOUTP CLKN VSS VSS sg13_lv_nmos w=0.15u l=0.13u ng=1 m=30
XM3 net1 CTRL VOUTN VSS sg13_lv_nmos w=0.15u l=0.13u ng=1 m=2
XM4 net2 CTRL VOUTP VSS sg13_lv_nmos w=0.15u l=0.13u ng=1 m=2
XM6 VOUTP net1 VDD VDD sg13_lv_pmos w=0.15u l=0.13u ng=1 m=15
XM5 VOUTN net2 VDD VDD sg13_lv_pmos w=0.15u l=0.13u ng=1 m=15
XM7 VOUTN VSS VDD VDD sg13_lv_pmos w=0.15u l=0.13u ng=1 m=20
XM8 VOUTP VSS VDD VDD sg13_lv_pmos w=0.15u l=0.13u ng=1 m=20
XM10 CTRL VOUTP net3 CTRL sg13_lv_pmos w=0.15u l=0.13u ng=1 m=20
XM9 CTRL VOUTN CTRL CTRL sg13_lv_pmos w=0.15u l=0.13u ng=1 m=20
**.ends
.end
