* Extracted by KLayout with SG13G2 LVS runset on : 26/03/2026 04:15

.SUBCKT 8xPI_top VSS VCONT VOUT VS[4] VS[3] VDD VS[2] VS[1] VS[0]
X$1 VSS VCONT \$7 VDD \$9 \$13 \$19 clock_gen
X$2 VSS VSS VSS VSS VSS VSS VSS VSS VDD VS[2] VS[1] VS[0] 3to7_deco_v2
X$3 VSS VS[4] \$28 VDD VS[3] \$15 VSS \$3 VSS \$5 VSS \$6 VSS \$10 VSS \$12 VSS
+ \$17 \$24 VSS 8xPI_logic
X$4 VSS \$13 \$28 \$19 \$7 VS[4] \$3 \$9 VDD \$5 \$6 \$10 VOUT \$12 \$17 \$24
+ \$15 8xPI
.ENDS 8xPI_top

.SUBCKT 8xPI VSS VINQB VS[1] VINQ VINIB VS[0] VST[7] VINI VDD VST[6] VST[5]
+ VST[4] VOUT VST[3] VST[2] VST[1] VST[0]
X$1 VSS VDD VINQB VST[7] VS[1] VINQ \$5 VINIB VS[0] VINI MUX_4_1
X$2 VSS VDD VINQB VST[4] VS[1] VINQ \$5 VINIB VS[0] VINI MUX_4_1
X$3 VSS VDD VINQB VST[6] VS[1] VINQ \$5 VINIB VS[0] VINI MUX_4_1
X$4 VSS VDD VINQB VST[0] VS[1] VINQ \$5 VINIB VS[0] VINI MUX_4_1
X$5 VSS VDD VINQB VST[1] VS[1] VINQ \$5 VINIB VS[0] VINI MUX_4_1
X$6 VSS VDD VINQB VST[2] VS[1] VINQ \$5 VINIB VS[0] VINI MUX_4_1
X$7 VSS VDD VINQB VST[3] VS[1] VINQ \$5 VINIB VS[0] VINI MUX_4_1
X$8 VSS VDD VINQB VST[5] VS[1] VINQ \$5 VINIB VS[0] VINI MUX_4_1
X$9 VSS \$5 VDD \$44 inv_PI
X$10 VSS VDD \$44 VOUT buff_PI_d16
.ENDS 8xPI

.SUBCKT 8xPI_logic VSS S[4] \$4 VDD S[3] SQ[2] ST[7] STQ[7] ST[6] STQ[6] ST[5]
+ STQ[5] ST[4] STQ[4] ST[3] STQ[3] ST[2] STQ[2] STQ[1] ST[1]
X$1 VSS VDD S[3] \$28 buff_d8
X$2 S[3] SQ[0] S[4] VSS VDD xor_custom
X$7 ST[1] STQ[1] \$103 VSS VDD xor_custom
X$9 ST[2] STQ[2] \$89 VSS VDD xor_custom
X$13 ST[3] STQ[3] \$78 VSS VDD xor_custom
X$16 ST[7] STQ[7] \$30 VSS VDD xor_custom
X$19 ST[6] STQ[6] \$42 VSS VDD xor_custom
X$22 ST[5] STQ[5] \$54 VSS VDD xor_custom
X$27 ST[4] STQ[4] \$66 VSS VDD xor_custom
M$1 VSS \$102 \$103 VSS sg13_lv_nmos L=0.13u W=0.15u AS=0.1005p AD=0.1005p
+ PS=1.34u PD=1.34u
M$2 VSS \$28 \$91 VSS sg13_lv_nmos L=0.13u W=0.15u AS=0.1005p AD=0.1005p
+ PS=1.34u PD=1.34u
M$3 VSS \$91 \$89 VSS sg13_lv_nmos L=0.13u W=0.15u AS=0.1005p AD=0.1005p
+ PS=1.34u PD=1.34u
M$4 VSS \$28 \$65 VSS sg13_lv_nmos L=0.13u W=0.15u AS=0.1005p AD=0.1005p
+ PS=1.34u PD=1.34u
M$5 VSS \$28 \$41 VSS sg13_lv_nmos L=0.13u W=0.15u AS=0.1005p AD=0.1005p
+ PS=1.34u PD=1.34u
M$6 VSS \$18 SQ[2] VSS sg13_lv_nmos L=0.13u W=0.15u AS=0.1005p AD=0.1005p
+ PS=1.34u PD=1.34u
M$7 VSS \$29 \$30 VSS sg13_lv_nmos L=0.13u W=0.15u AS=0.1005p AD=0.1005p
+ PS=1.34u PD=1.34u
M$8 VSS S[3] \$18 VSS sg13_lv_nmos L=0.13u W=0.15u AS=0.1005p AD=0.1005p
+ PS=1.34u PD=1.34u
M$9 VSS \$28 \$56 VSS sg13_lv_nmos L=0.13u W=0.15u AS=0.1005p AD=0.1005p
+ PS=1.34u PD=1.34u
M$10 VSS \$28 \$29 VSS sg13_lv_nmos L=0.13u W=0.15u AS=0.1005p AD=0.1005p
+ PS=1.34u PD=1.34u
M$11 VSS \$4 SQ[1] VSS sg13_lv_nmos L=0.13u W=0.15u AS=0.1005p AD=0.1005p
+ PS=1.34u PD=1.34u
M$12 VSS S[4] \$4 VSS sg13_lv_nmos L=0.13u W=0.15u AS=0.1005p AD=0.1005p
+ PS=1.34u PD=1.34u
M$13 VSS \$65 \$66 VSS sg13_lv_nmos L=0.13u W=0.15u AS=0.1005p AD=0.1005p
+ PS=1.34u PD=1.34u
M$14 VSS \$28 \$102 VSS sg13_lv_nmos L=0.13u W=0.15u AS=0.1005p AD=0.1005p
+ PS=1.34u PD=1.34u
M$15 VSS \$28 \$77 VSS sg13_lv_nmos L=0.13u W=0.15u AS=0.1005p AD=0.1005p
+ PS=1.34u PD=1.34u
M$16 VSS \$56 \$54 VSS sg13_lv_nmos L=0.13u W=0.15u AS=0.1005p AD=0.1005p
+ PS=1.34u PD=1.34u
M$17 VSS \$41 \$42 VSS sg13_lv_nmos L=0.13u W=0.15u AS=0.1005p AD=0.1005p
+ PS=1.34u PD=1.34u
M$18 VSS \$77 \$78 VSS sg13_lv_nmos L=0.13u W=0.15u AS=0.1005p AD=0.1005p
+ PS=1.34u PD=1.34u
M$19 VDD \$102 \$103 VDD sg13_lv_pmos L=0.13u W=0.15u AS=0.1005p AD=0.1005p
+ PS=1.34u PD=1.34u
M$20 VDD \$91 \$89 VDD sg13_lv_pmos L=0.13u W=0.15u AS=0.1005p AD=0.1005p
+ PS=1.34u PD=1.34u
M$21 VDD \$28 \$91 VDD sg13_lv_pmos L=0.13u W=0.15u AS=0.1005p AD=0.1005p
+ PS=1.34u PD=1.34u
M$22 VDD \$28 \$41 VDD sg13_lv_pmos L=0.13u W=0.15u AS=0.1005p AD=0.1005p
+ PS=1.34u PD=1.34u
M$23 VDD \$29 \$30 VDD sg13_lv_pmos L=0.13u W=0.15u AS=0.1005p AD=0.1005p
+ PS=1.34u PD=1.34u
M$24 VDD \$28 \$29 VDD sg13_lv_pmos L=0.13u W=0.15u AS=0.1005p AD=0.1005p
+ PS=1.34u PD=1.34u
M$25 VDD S[3] \$18 VDD sg13_lv_pmos L=0.13u W=0.15u AS=0.1005p AD=0.1005p
+ PS=1.34u PD=1.34u
M$26 VDD \$77 \$78 VDD sg13_lv_pmos L=0.13u W=0.15u AS=0.1005p AD=0.1005p
+ PS=1.34u PD=1.34u
M$27 VDD \$18 SQ[2] VDD sg13_lv_pmos L=0.13u W=0.15u AS=0.1005p AD=0.1005p
+ PS=1.34u PD=1.34u
M$28 VDD \$4 SQ[1] VDD sg13_lv_pmos L=0.13u W=0.15u AS=0.1005p AD=0.1005p
+ PS=1.34u PD=1.34u
M$29 VDD \$28 \$102 VDD sg13_lv_pmos L=0.13u W=0.15u AS=0.1005p AD=0.1005p
+ PS=1.34u PD=1.34u
M$30 VDD \$28 \$77 VDD sg13_lv_pmos L=0.13u W=0.15u AS=0.1005p AD=0.1005p
+ PS=1.34u PD=1.34u
M$31 VDD \$28 \$56 VDD sg13_lv_pmos L=0.13u W=0.15u AS=0.1005p AD=0.1005p
+ PS=1.34u PD=1.34u
M$32 VDD S[4] \$4 VDD sg13_lv_pmos L=0.13u W=0.15u AS=0.1005p AD=0.1005p
+ PS=1.34u PD=1.34u
M$33 VDD \$65 \$66 VDD sg13_lv_pmos L=0.13u W=0.15u AS=0.1005p AD=0.1005p
+ PS=1.34u PD=1.34u
M$34 VDD \$41 \$42 VDD sg13_lv_pmos L=0.13u W=0.15u AS=0.1005p AD=0.1005p
+ PS=1.34u PD=1.34u
M$35 VDD \$56 \$54 VDD sg13_lv_pmos L=0.13u W=0.15u AS=0.1005p AD=0.1005p
+ PS=1.34u PD=1.34u
M$36 VDD \$28 \$65 VDD sg13_lv_pmos L=0.13u W=0.15u AS=0.1005p AD=0.1005p
+ PS=1.34u PD=1.34u
.ENDS 8xPI_logic

.SUBCKT clock_gen VSS CTRL PH180 VDD PH0 PH270 PH90
X$1 VSS \$5 VDD PH180 \$3 PH0 \$8 \$6 \$4 PH270 \$7 PH90 6to4
X$2 VSS VDD CTRL \$3 \$5 \$6 \$7 \$4 \$8 6ph_rosc
.ENDS clock_gen

.SUBCKT 3to7_deco_v2 VSS ST[1] ST[2] ST[3] ST[4] ST[5] ST[6] ST[7] VDD S[2]
+ S[1] S[0]
X$1 VSS \$12 \$11 VDD \$10 and_custom
X$2 VSS VDD \$11 \$12 \$14 or_custom
X$3 \$12 \$13 VDD VSS \$11 ST[7] nand_x3_custom
X$4 \$13 \$14 VDD VSS ST[5] nand_custom
X$5 \$13 \$12 VDD VSS ST[6] nand_custom
X$10 VDD VSS \$13 \$10 ST[3] nor_custom
X$11 VDD VSS \$13 \$12 ST[2] nor_custom
X$12 VDD VSS \$13 \$12 \$11 ST[1] nor_x3_custom
M$1 VSS \$13 ST[4] VSS sg13_lv_nmos L=0.13u W=0.15u AS=0.1005p AD=0.1005p
+ PS=1.34u PD=1.34u
M$2 VSS S[2] \$13 VSS sg13_lv_nmos L=0.13u W=0.15u AS=0.1005p AD=0.1005p
+ PS=1.34u PD=1.34u
M$3 VSS S[1] \$12 VSS sg13_lv_nmos L=0.13u W=0.15u AS=0.1005p AD=0.1005p
+ PS=1.34u PD=1.34u
M$4 VSS S[0] \$11 VSS sg13_lv_nmos L=0.13u W=0.15u AS=0.1005p AD=0.1005p
+ PS=1.34u PD=1.34u
M$5 VDD \$13 ST[4] VDD sg13_lv_pmos L=0.13u W=0.15u AS=0.1005p AD=0.1005p
+ PS=1.34u PD=1.34u
M$6 VDD S[2] \$13 VDD sg13_lv_pmos L=0.13u W=0.15u AS=0.1005p AD=0.1005p
+ PS=1.34u PD=1.34u
M$7 VDD S[1] \$12 VDD sg13_lv_pmos L=0.13u W=0.15u AS=0.1005p AD=0.1005p
+ PS=1.34u PD=1.34u
M$8 VDD S[0] \$11 VDD sg13_lv_pmos L=0.13u W=0.15u AS=0.1005p AD=0.1005p
+ PS=1.34u PD=1.34u
.ENDS 3to7_deco_v2

.SUBCKT buff_PI_d16 VSS VDD VIN VOUT
X$1 \$9 VSS \$13 VDD inv_PI_d8
X$2 VSS VDD \$13 VOUT inv_PI_d16
X$3 \$6 VSS \$9 VDD inv_PI_d4
X$4 VSS VIN \$6 VDD inv_PI_d2
.ENDS buff_PI_d16

.SUBCKT MUX_4_1 VSS VDD VIND VST VS[1] VINC VOUT VINB VS[0] VINA
X$1 VSS VINB \$10 VS[0] VDD VINA MUX_2_1
X$2 VSS \$4 VOUT VST VDD \$10 MUX_2_1
X$3 VSS VIND \$4 VS[1] VDD VINC MUX_2_1
.ENDS MUX_4_1

.SUBCKT xor_custom B VOUT A VSS VDD
X$2 VDD A VSS \$1 VOUT B inv_xor
M$1 VSS B \$1 VSS sg13_lv_nmos L=0.13u W=0.15u AS=0.1005p AD=0.1005p PS=1.34u
+ PD=1.34u
M$2 VDD B \$1 VDD sg13_lv_pmos L=0.13u W=0.15u AS=0.1005p AD=0.1005p PS=1.34u
+ PD=1.34u
M$3 VOUT B A VDD sg13_lv_pmos L=0.13u W=0.3u AS=0.156p AD=0.156p PS=2.08u
+ PD=2.08u
M$5 VOUT \$1 A VSS sg13_lv_nmos L=0.13u W=0.15u AS=0.1005p AD=0.1005p PS=1.34u
+ PD=1.34u
.ENDS xor_custom

.SUBCKT buff_d8 VSS VDD VIN VOUT
X$1 \$1 VSS VDD \$2 inv_d2
X$3 \$3 \$2 VSS VDD inv_d4
X$4 VOUT \$3 VSS VDD inv_d8
M$1 VSS VIN \$1 VSS sg13_lv_nmos L=0.13u W=0.15u AS=0.1005p AD=0.1005p PS=1.34u
+ PD=1.34u
M$2 VDD VIN \$1 VDD sg13_lv_pmos L=0.13u W=0.15u AS=0.1005p AD=0.1005p PS=1.34u
+ PD=1.34u
.ENDS buff_d8

.SUBCKT 6ph_rosc VSS VDD CTRL PH0 PH3 PH4 PH1 PH2 PH5
X$1 PH0 PH3 VSS VDD flywheel
X$2 PH2 PH5 VSS VDD flywheel
X$3 PH4 PH1 VSS VDD flywheel
X$4 VSS VDD \$3 CTRL \$26 \$2 \$28 psdiff
X$5 VSS VDD \$2 CTRL \$24 \$16 \$26 psdiff
X$6 VSS VDD \$16 CTRL \$28 \$3 \$24 psdiff
X$8 CTRL PH1 PH4 VDD decap
X$10 CTRL PH0 PH3 VDD decap
X$11 CTRL PH2 PH5 VDD decap
M$1 VSS \$28 \$I57 VSS sg13_lv_nmos L=0.13u W=0.15u AS=0.1005p AD=0.1005p
+ PS=1.34u PD=1.34u
M$2 VDD \$28 \$I57 VDD sg13_lv_pmos L=0.13u W=0.15u AS=0.1005p AD=0.1005p
+ PS=1.34u PD=1.34u
M$3 VSS \$26 \$I60 VSS sg13_lv_nmos L=0.13u W=0.15u AS=0.1005p AD=0.1005p
+ PS=1.34u PD=1.34u
M$4 VDD \$26 \$I60 VDD sg13_lv_pmos L=0.13u W=0.15u AS=0.1005p AD=0.1005p
+ PS=1.34u PD=1.34u
M$5 VSS \$24 \$I63 VSS sg13_lv_nmos L=0.13u W=0.15u AS=0.1005p AD=0.1005p
+ PS=1.34u PD=1.34u
M$6 VDD \$24 \$I63 VDD sg13_lv_pmos L=0.13u W=0.15u AS=0.1005p AD=0.1005p
+ PS=1.34u PD=1.34u
M$7 VSS \$2 \$I66 VSS sg13_lv_nmos L=0.13u W=0.15u AS=0.1005p AD=0.1005p
+ PS=1.34u PD=1.34u
M$8 VDD \$2 \$I66 VDD sg13_lv_pmos L=0.13u W=0.15u AS=0.1005p AD=0.1005p
+ PS=1.34u PD=1.34u
M$9 VSS \$3 \$I69 VSS sg13_lv_nmos L=0.13u W=0.15u AS=0.1005p AD=0.1005p
+ PS=1.34u PD=1.34u
M$10 VDD \$3 \$I69 VDD sg13_lv_pmos L=0.13u W=0.15u AS=0.1005p AD=0.1005p
+ PS=1.34u PD=1.34u
M$11 VSS \$16 \$I72 VSS sg13_lv_nmos L=0.13u W=0.15u AS=0.1005p AD=0.1005p
+ PS=1.34u PD=1.34u
M$12 VDD \$16 \$I72 VDD sg13_lv_pmos L=0.13u W=0.15u AS=0.1005p AD=0.1005p
+ PS=1.34u PD=1.34u
M$13 VSS \$I57 \$I58 VSS sg13_lv_nmos L=0.13u W=0.3u AS=0.156p AD=0.156p
+ PS=2.08u PD=2.08u
M$15 VDD \$I57 \$I58 VDD sg13_lv_pmos L=0.13u W=0.3u AS=0.156p AD=0.156p
+ PS=2.08u PD=2.08u
M$17 VSS \$I60 \$I61 VSS sg13_lv_nmos L=0.13u W=0.3u AS=0.156p AD=0.156p
+ PS=2.08u PD=2.08u
M$19 VDD \$I60 \$I61 VDD sg13_lv_pmos L=0.13u W=0.3u AS=0.156p AD=0.156p
+ PS=2.08u PD=2.08u
M$21 VSS \$I63 \$I64 VSS sg13_lv_nmos L=0.13u W=0.3u AS=0.156p AD=0.156p
+ PS=2.08u PD=2.08u
M$23 VDD \$I63 \$I64 VDD sg13_lv_pmos L=0.13u W=0.3u AS=0.156p AD=0.156p
+ PS=2.08u PD=2.08u
M$25 VSS \$I66 \$I67 VSS sg13_lv_nmos L=0.13u W=0.3u AS=0.156p AD=0.156p
+ PS=2.08u PD=2.08u
M$27 VDD \$I66 \$I67 VDD sg13_lv_pmos L=0.13u W=0.3u AS=0.156p AD=0.156p
+ PS=2.08u PD=2.08u
M$29 VSS \$I69 \$I70 VSS sg13_lv_nmos L=0.13u W=0.3u AS=0.156p AD=0.156p
+ PS=2.08u PD=2.08u
M$31 VDD \$I69 \$I70 VDD sg13_lv_pmos L=0.13u W=0.3u AS=0.156p AD=0.156p
+ PS=2.08u PD=2.08u
M$33 VSS \$I72 \$I73 VSS sg13_lv_nmos L=0.13u W=0.3u AS=0.156p AD=0.156p
+ PS=2.08u PD=2.08u
M$35 VDD \$I72 \$I73 VDD sg13_lv_pmos L=0.13u W=0.3u AS=0.156p AD=0.156p
+ PS=2.08u PD=2.08u
M$37 VSS \$I58 \$I59 VSS sg13_lv_nmos L=0.13u W=0.6u AS=0.312p AD=0.312p
+ PS=4.16u PD=4.16u
M$39 VDD \$I58 \$I59 VDD sg13_lv_pmos L=0.13u W=0.6u AS=0.312p AD=0.312p
+ PS=4.16u PD=4.16u
M$45 VSS \$I61 \$I62 VSS sg13_lv_nmos L=0.13u W=0.6u AS=0.312p AD=0.312p
+ PS=4.16u PD=4.16u
M$47 VDD \$I61 \$I62 VDD sg13_lv_pmos L=0.13u W=0.6u AS=0.312p AD=0.312p
+ PS=4.16u PD=4.16u
M$53 VSS \$I64 \$I65 VSS sg13_lv_nmos L=0.13u W=0.6u AS=0.312p AD=0.312p
+ PS=4.16u PD=4.16u
M$55 VDD \$I64 \$I65 VDD sg13_lv_pmos L=0.13u W=0.6u AS=0.312p AD=0.312p
+ PS=4.16u PD=4.16u
M$61 VSS \$I67 \$I68 VSS sg13_lv_nmos L=0.13u W=0.6u AS=0.312p AD=0.312p
+ PS=4.16u PD=4.16u
M$63 VDD \$I67 \$I68 VDD sg13_lv_pmos L=0.13u W=0.6u AS=0.312p AD=0.312p
+ PS=4.16u PD=4.16u
M$69 VSS \$I70 \$I71 VSS sg13_lv_nmos L=0.13u W=0.6u AS=0.312p AD=0.312p
+ PS=4.16u PD=4.16u
M$71 VDD \$I70 \$I71 VDD sg13_lv_pmos L=0.13u W=0.6u AS=0.312p AD=0.312p
+ PS=4.16u PD=4.16u
M$77 VSS \$I73 \$I74 VSS sg13_lv_nmos L=0.13u W=0.6u AS=0.312p AD=0.312p
+ PS=4.16u PD=4.16u
M$79 VDD \$I73 \$I74 VDD sg13_lv_pmos L=0.13u W=0.6u AS=0.312p AD=0.312p
+ PS=4.16u PD=4.16u
M$85 VSS \$I59 PH4 VSS sg13_lv_nmos L=0.13u W=1.2u AS=0.624p AD=0.624p PS=8.32u
+ PD=8.32u
M$87 VDD \$I59 PH4 VDD sg13_lv_pmos L=0.13u W=1.2u AS=0.624p AD=0.624p PS=8.32u
+ PD=8.32u
M$101 VSS \$I62 PH0 VSS sg13_lv_nmos L=0.13u W=1.2u AS=0.624p AD=0.624p
+ PS=8.32u PD=8.32u
M$103 VDD \$I62 PH0 VDD sg13_lv_pmos L=0.13u W=1.2u AS=0.624p AD=0.624p
+ PS=8.32u PD=8.32u
M$117 VSS \$I65 PH2 VSS sg13_lv_nmos L=0.13u W=1.2u AS=0.624p AD=0.624p
+ PS=8.32u PD=8.32u
M$119 VDD \$I65 PH2 VDD sg13_lv_pmos L=0.13u W=1.2u AS=0.624p AD=0.624p
+ PS=8.32u PD=8.32u
M$133 VSS \$I68 PH3 VSS sg13_lv_nmos L=0.13u W=1.2u AS=0.624p AD=0.624p
+ PS=8.32u PD=8.32u
M$135 VDD \$I68 PH3 VDD sg13_lv_pmos L=0.13u W=1.2u AS=0.624p AD=0.624p
+ PS=8.32u PD=8.32u
M$149 VSS \$I71 PH1 VSS sg13_lv_nmos L=0.13u W=1.2u AS=0.624p AD=0.624p
+ PS=8.32u PD=8.32u
M$151 VDD \$I71 PH1 VDD sg13_lv_pmos L=0.13u W=1.2u AS=0.624p AD=0.624p
+ PS=8.32u PD=8.32u
M$165 VSS \$I74 PH5 VSS sg13_lv_nmos L=0.13u W=1.2u AS=0.624p AD=0.624p
+ PS=8.32u PD=8.32u
M$167 VDD \$I74 PH5 VDD sg13_lv_pmos L=0.13u W=1.2u AS=0.624p AD=0.624p
+ PS=8.32u PD=8.32u
.ENDS 6ph_rosc

.SUBCKT 6to4 VSS V3 VDD PH180 V0 PH0 V5 V4 V2 PH270 V1 PH90
X$1 \$24 \$18 VSS VDD flywheel_clk
X$2 VSS VDD V1 V2 \$24 PI_clk
X$3 VSS VDD PH90 \$24 buff_PI_d32
X$4 VSS VDD PH0 \$9 buff_PI_d32
X$5 \$9 \$2 VSS VDD flywheel_clk
X$8 VSS VDD PH270 \$18 buff_PI_d32
X$9 VSS VDD V4 V5 \$18 PI_clk
X$12 VSS VDD PH180 \$2 buff_PI_d32
M$1 VDD \$15 \$9 VDD sg13_lv_pmos L=0.13u W=0.9u AS=0.423p AD=0.423p PS=5.64u
+ PD=5.64u
M$7 VDD V0 \$15 VDD sg13_lv_pmos L=0.13u W=0.9u AS=0.423p AD=0.423p PS=5.64u
+ PD=5.64u
M$13 VDD V3 \$6 VDD sg13_lv_pmos L=0.13u W=0.9u AS=0.423p AD=0.423p PS=5.64u
+ PD=5.64u
M$19 VDD \$6 \$2 VDD sg13_lv_pmos L=0.13u W=0.9u AS=0.423p AD=0.423p PS=5.64u
+ PD=5.64u
M$25 VSS \$15 \$9 VSS sg13_lv_nmos L=0.13u W=0.6u AS=0.312p AD=0.312p PS=4.16u
+ PD=4.16u
M$29 VSS V0 \$15 VSS sg13_lv_nmos L=0.13u W=0.6u AS=0.312p AD=0.312p PS=4.16u
+ PD=4.16u
M$33 VSS V3 \$6 VSS sg13_lv_nmos L=0.13u W=0.6u AS=0.312p AD=0.312p PS=4.16u
+ PD=4.16u
M$37 VSS \$6 \$2 VSS sg13_lv_nmos L=0.13u W=0.6u AS=0.312p AD=0.312p PS=4.16u
+ PD=4.16u
.ENDS 6to4

.SUBCKT nand_x3_custom B C VDD VSS A OUT
M$1 OUT A \$7 VSS sg13_lv_nmos L=0.13u W=0.15u AS=0.1005p AD=0.0555p PS=1.34u
+ PD=0.74u
M$2 \$7 B \$8 VSS sg13_lv_nmos L=0.13u W=0.15u AS=0.0555p AD=0.0555p PS=0.74u
+ PD=0.74u
M$3 \$8 C VSS VSS sg13_lv_nmos L=0.13u W=0.15u AS=0.0555p AD=0.1005p PS=0.74u
+ PD=1.34u
M$4 VDD A OUT VDD sg13_lv_pmos L=0.13u W=0.15u AS=0.1005p AD=0.0555p PS=1.34u
+ PD=0.74u
M$5 OUT B VDD VDD sg13_lv_pmos L=0.13u W=0.15u AS=0.0555p AD=0.0555p PS=0.74u
+ PD=0.74u
M$6 VDD C OUT VDD sg13_lv_pmos L=0.13u W=0.15u AS=0.0555p AD=0.1005p PS=0.74u
+ PD=1.34u
.ENDS nand_x3_custom

.SUBCKT or_custom VSS VDD A B OUT
X$1 VDD VSS B A \$2 nor_custom
M$1 VSS \$2 OUT VSS sg13_lv_nmos L=0.13u W=0.15u AS=0.1005p AD=0.1005p PS=1.34u
+ PD=1.34u
M$2 VDD \$2 OUT VDD sg13_lv_pmos L=0.13u W=0.15u AS=0.1005p AD=0.1005p PS=1.34u
+ PD=1.34u
.ENDS or_custom

.SUBCKT and_custom VSS A B VDD OUT
X$1 B A VDD VSS \$1 nand_custom
M$1 VSS \$1 OUT VSS sg13_lv_nmos L=0.13u W=0.15u AS=0.1005p AD=0.1005p PS=1.34u
+ PD=1.34u
M$2 VDD \$1 OUT VDD sg13_lv_pmos L=0.13u W=0.15u AS=0.1005p AD=0.1005p PS=1.34u
+ PD=1.34u
.ENDS and_custom

.SUBCKT nor_x3_custom VDD VSS C B A OUT
M$1 VSS A OUT VSS sg13_lv_nmos L=0.13u W=0.15u AS=0.1005p AD=0.0555p PS=1.34u
+ PD=0.74u
M$2 OUT B VSS VSS sg13_lv_nmos L=0.13u W=0.15u AS=0.0555p AD=0.0555p PS=0.74u
+ PD=0.74u
M$3 VSS C OUT VSS sg13_lv_nmos L=0.13u W=0.15u AS=0.0555p AD=0.1005p PS=0.74u
+ PD=1.34u
M$4 VDD A \$7 VDD sg13_lv_pmos L=0.13u W=0.15u AS=0.1005p AD=0.0555p PS=1.34u
+ PD=0.74u
M$5 \$7 B \$8 VDD sg13_lv_pmos L=0.13u W=0.15u AS=0.0555p AD=0.0555p PS=0.74u
+ PD=0.74u
M$6 \$8 C OUT VDD sg13_lv_pmos L=0.13u W=0.15u AS=0.0555p AD=0.1005p PS=0.74u
+ PD=1.34u
.ENDS nor_x3_custom

.SUBCKT inv_PI_d16 VSS VDD VIN VOUT
X$1 VIN VSS VOUT VDD inv_PI_d8
X$2 VIN VSS VOUT VDD inv_PI_d8
.ENDS inv_PI_d16

.SUBCKT MUX_2_1 VSS VINB VOUT VS VDD VINA
X$1 VSS \$15 \$8 \$10 \$20 VDD tg_custom
X$2 VSS VDD \$10 tieh_custom
X$3 VSS \$15 \$14 VS \$20 VDD tg_custom
X$4 VSS VOUT \$10 \$8 \$15 VDD tg_custom
X$5 VSS \$15 \$14 VS \$20 VDD tg_custom
X$6 VSS VINA VDD \$20 inv_PI
X$7 VDD VS VSS \$14 inv
X$8 VSS \$5 \$8 \$10 \$9 VDD tg_custom
X$9 VSS VDD \$8 tiel_custom
X$10 VSS VINB VDD \$9 inv_PI
X$11 VSS \$5 VS \$14 \$9 VDD tg_custom
X$12 VSS VOUT \$10 \$8 \$5 VDD tg_custom
X$13 VSS \$5 \$8 \$10 \$9 VDD tg_custom
.ENDS MUX_2_1

.SUBCKT inv_xor VBP VIN VBN VSS VOUT VDD
M$1 VDD VIN VOUT VBP sg13_lv_pmos L=0.13u W=0.15u AS=0.1005p AD=0.1005p
+ PS=1.34u PD=1.34u
M$2 VSS VIN VOUT VBN sg13_lv_nmos L=0.13u W=0.15u AS=0.1005p AD=0.1005p
+ PS=1.34u PD=1.34u
.ENDS inv_xor

.SUBCKT inv_d8 VOUT VIN VSS VDD
X$1 VOUT VIN VSS VDD inv_d4
X$2 VOUT VIN VSS VDD inv_d4
.ENDS inv_d8

.SUBCKT flywheel PH1 PH0 VSS VDD
M$1 VSS PH0 PH1 VSS sg13_lv_nmos L=0.13u W=0.3u AS=0.156p AD=0.156p PS=2.08u
+ PD=2.08u
M$3 VDD PH0 PH1 VDD sg13_lv_pmos L=0.13u W=0.3u AS=0.156p AD=0.156p PS=2.08u
+ PD=2.08u
M$5 VSS PH1 PH0 VSS sg13_lv_nmos L=0.13u W=0.3u AS=0.156p AD=0.156p PS=2.08u
+ PD=2.08u
M$7 VDD PH1 PH0 VDD sg13_lv_pmos L=0.13u W=0.3u AS=0.156p AD=0.156p PS=2.08u
+ PD=2.08u
.ENDS flywheel

.SUBCKT decap CTRL VOUTDN VOUTDP VDD
M$1 CTRL VOUTDN CTRL VDD sg13_lv_pmos L=0.13u W=32u AS=6.68p AD=6.08p PS=49.36u
+ PD=44.16u
M$9 CTRL VOUTDP CTRL VDD sg13_lv_pmos L=0.13u W=32u AS=6.08p AD=6.68p PS=44.16u
+ PD=49.36u
.ENDS decap

.SUBCKT psdiff VSS VDD VOUTDP CTRL CLKP CLKN VOUTDN
M$1 VSS CLKP \$7 VSS sg13_lv_nmos L=0.13u W=4.5u AS=1.8p AD=1.665p PS=24u
+ PD=22.2u
M$11 VSS CLKN \$3 VSS sg13_lv_nmos L=0.13u W=4.5u AS=1.665p AD=1.8p PS=22.2u
+ PD=24u
M$61 VDD VSS \$3 VDD sg13_lv_pmos L=0.13u W=3u AS=1.2p AD=1.11p PS=16u PD=14.8u
M$71 VDD VSS \$7 VDD sg13_lv_pmos L=0.13u W=3u AS=1.11p AD=1.2p PS=14.8u PD=16u
M$101 VDD \$84 \$3 VDD sg13_lv_pmos L=0.13u W=1.5u AS=0.6p AD=0.555p PS=8u
+ PD=7.4u
M$111 VDD \$86 \$7 VDD sg13_lv_pmos L=0.13u W=1.5u AS=0.555p AD=0.6p PS=7.4u
+ PD=8u
M$121 \$7 CTRL \$84 VSS sg13_lv_nmos L=0.13u W=0.3u AS=0.156p AD=0.156p
+ PS=2.08u PD=2.08u
M$123 \$3 CTRL \$86 VSS sg13_lv_nmos L=0.13u W=0.3u AS=0.156p AD=0.156p
+ PS=2.08u PD=2.08u
M$125 VSS \$3 \$I715 VSS sg13_lv_nmos L=0.13u W=0.15u AS=0.1005p AD=0.1005p
+ PS=1.34u PD=1.34u
M$126 VDD \$3 \$I715 VDD sg13_lv_pmos L=0.13u W=0.15u AS=0.1005p AD=0.1005p
+ PS=1.34u PD=1.34u
M$127 VSS \$7 \$I718 VSS sg13_lv_nmos L=0.13u W=0.15u AS=0.1005p AD=0.1005p
+ PS=1.34u PD=1.34u
M$128 VDD \$7 \$I718 VDD sg13_lv_pmos L=0.13u W=0.15u AS=0.1005p AD=0.1005p
+ PS=1.34u PD=1.34u
M$129 VSS \$I715 \$I716 VSS sg13_lv_nmos L=0.13u W=0.3u AS=0.156p AD=0.156p
+ PS=2.08u PD=2.08u
M$131 VDD \$I715 \$I716 VDD sg13_lv_pmos L=0.13u W=0.3u AS=0.156p AD=0.156p
+ PS=2.08u PD=2.08u
M$133 VSS \$I718 \$I719 VSS sg13_lv_nmos L=0.13u W=0.3u AS=0.156p AD=0.156p
+ PS=2.08u PD=2.08u
M$135 VDD \$I718 \$I719 VDD sg13_lv_pmos L=0.13u W=0.3u AS=0.156p AD=0.156p
+ PS=2.08u PD=2.08u
M$137 VSS \$I716 \$I717 VSS sg13_lv_nmos L=0.13u W=0.6u AS=0.312p AD=0.312p
+ PS=4.16u PD=4.16u
M$139 VDD \$I716 \$I717 VDD sg13_lv_pmos L=0.13u W=0.6u AS=0.312p AD=0.312p
+ PS=4.16u PD=4.16u
M$145 VSS \$I719 \$I720 VSS sg13_lv_nmos L=0.13u W=0.6u AS=0.312p AD=0.312p
+ PS=4.16u PD=4.16u
M$147 VDD \$I719 \$I720 VDD sg13_lv_pmos L=0.13u W=0.6u AS=0.312p AD=0.312p
+ PS=4.16u PD=4.16u
M$153 VSS \$I717 VOUTDP VSS sg13_lv_nmos L=0.13u W=1.2u AS=0.624p AD=0.624p
+ PS=8.32u PD=8.32u
M$155 VDD \$I717 VOUTDP VDD sg13_lv_pmos L=0.13u W=1.2u AS=0.624p AD=0.624p
+ PS=8.32u PD=8.32u
M$169 VSS \$I720 VOUTDN VSS sg13_lv_nmos L=0.13u W=1.2u AS=0.624p AD=0.624p
+ PS=8.32u PD=8.32u
M$171 VDD \$I720 VOUTDN VDD sg13_lv_pmos L=0.13u W=1.2u AS=0.624p AD=0.624p
+ PS=8.32u PD=8.32u
.ENDS psdiff

.SUBCKT flywheel_clk PH0 PH1 VSS VDD
M$1 VSS PH1 PH0 VSS sg13_lv_nmos L=0.13u W=0.3u AS=0.156p AD=0.156p PS=2.08u
+ PD=2.08u
M$3 VDD PH1 PH0 VDD sg13_lv_pmos L=0.13u W=0.3u AS=0.156p AD=0.156p PS=2.08u
+ PD=2.08u
M$5 VSS PH0 PH1 VSS sg13_lv_nmos L=0.13u W=0.6u AS=0.312p AD=0.312p PS=4.16u
+ PD=4.16u
M$7 VDD PH0 PH1 VDD sg13_lv_pmos L=0.13u W=0.6u AS=0.312p AD=0.312p PS=4.16u
+ PD=4.16u
.ENDS flywheel_clk

.SUBCKT PI_clk VSS VDD PH0 PH1 PHOUT
M$1 VDD PH0 \$1 VDD sg13_lv_pmos L=0.13u W=0.9u AS=0.423p AD=0.423p PS=5.64u
+ PD=5.64u
M$7 VDD PH1 \$1 VDD sg13_lv_pmos L=0.13u W=0.9u AS=0.423p AD=0.423p PS=5.64u
+ PD=5.64u
M$13 VDD \$1 PHOUT VDD sg13_lv_pmos L=0.13u W=0.9u AS=0.423p AD=0.423p PS=5.64u
+ PD=5.64u
M$19 VSS PH0 \$1 VSS sg13_lv_nmos L=0.13u W=0.6u AS=0.312p AD=0.312p PS=4.16u
+ PD=4.16u
M$23 VSS PH1 \$1 VSS sg13_lv_nmos L=0.13u W=0.6u AS=0.312p AD=0.312p PS=4.16u
+ PD=4.16u
M$27 VSS \$1 PHOUT VSS sg13_lv_nmos L=0.13u W=0.6u AS=0.312p AD=0.312p PS=4.16u
+ PD=4.16u
.ENDS PI_clk

.SUBCKT buff_PI_d32 VSS VDD VOUT VIN
X$3 VOUT \$8 VSS VDD inv_PI_d32
M$1 VDD VIN \$I5 VDD sg13_lv_pmos L=0.13u W=0.9u AS=0.423p AD=0.423p PS=5.64u
+ PD=5.64u
M$7 VDD \$I5 \$I6 VDD sg13_lv_pmos L=0.13u W=1.8u AS=0.846p AD=0.846p PS=11.28u
+ PD=11.28u
M$19 VDD \$I6 \$I7 VDD sg13_lv_pmos L=0.13u W=3.6u AS=1.692p AD=1.692p
+ PS=22.56u PD=22.56u
M$43 VDD \$6 \$8 VDD sg13_lv_pmos L=0.13u W=7.2u AS=3.384p AD=3.384p PS=45.12u
+ PD=45.12u
M$91 VDD \$I7 \$6 VDD sg13_lv_pmos L=0.13u W=7.2u AS=3.384p AD=3.384p PS=45.12u
+ PD=45.12u
M$139 VSS VIN \$I5 VSS sg13_lv_nmos L=0.13u W=0.6u AS=0.312p AD=0.312p PS=4.16u
+ PD=4.16u
M$143 VSS \$I5 \$I6 VSS sg13_lv_nmos L=0.13u W=1.2u AS=0.624p AD=0.624p
+ PS=8.32u PD=8.32u
M$151 VSS \$I6 \$I7 VSS sg13_lv_nmos L=0.13u W=2.4u AS=1.248p AD=1.248p
+ PS=16.64u PD=16.64u
M$167 VSS \$6 \$8 VSS sg13_lv_nmos L=0.13u W=4.8u AS=2.496p AD=2.496p PS=33.28u
+ PD=33.28u
M$199 VSS \$I7 \$6 VSS sg13_lv_nmos L=0.13u W=4.8u AS=2.496p AD=2.496p
+ PS=33.28u PD=33.28u
.ENDS buff_PI_d32

.SUBCKT nand_custom B A VDD VSS OUT
M$1 OUT A \$6 VSS sg13_lv_nmos L=0.13u W=0.15u AS=0.1005p AD=0.0555p PS=1.34u
+ PD=0.74u
M$2 \$6 B VSS VSS sg13_lv_nmos L=0.13u W=0.15u AS=0.0555p AD=0.1005p PS=0.74u
+ PD=1.34u
M$3 VDD A OUT VDD sg13_lv_pmos L=0.13u W=0.15u AS=0.1005p AD=0.0555p PS=1.34u
+ PD=0.74u
M$4 OUT B VDD VDD sg13_lv_pmos L=0.13u W=0.15u AS=0.0555p AD=0.1005p PS=0.74u
+ PD=1.34u
.ENDS nand_custom

.SUBCKT nor_custom VDD VSS B A OUT
M$1 VSS A OUT VSS sg13_lv_nmos L=0.13u W=0.15u AS=0.1005p AD=0.0555p PS=1.34u
+ PD=0.74u
M$2 OUT B VSS VSS sg13_lv_nmos L=0.13u W=0.15u AS=0.0555p AD=0.1005p PS=0.74u
+ PD=1.34u
M$3 VDD A \$6 VDD sg13_lv_pmos L=0.13u W=0.15u AS=0.1005p AD=0.0555p PS=1.34u
+ PD=0.74u
M$4 \$6 B OUT VDD sg13_lv_pmos L=0.13u W=0.15u AS=0.0555p AD=0.1005p PS=0.74u
+ PD=1.34u
.ENDS nor_custom

.SUBCKT inv_PI_d8 VIN VSS VOUT VDD
X$1 VIN VSS VOUT VDD inv_PI_d4
X$2 VIN VSS VOUT VDD inv_PI_d4
.ENDS inv_PI_d8

.SUBCKT tieh_custom VSS VDD VOUT
M$1 VSS \$3 \$3 VSS sg13_lv_nmos L=0.13u W=0.15u AS=0.1005p AD=0.1005p PS=1.34u
+ PD=1.34u
M$2 VDD \$3 VOUT VDD sg13_lv_pmos L=0.13u W=0.15u AS=0.1005p AD=0.1005p
+ PS=1.34u PD=1.34u
.ENDS tieh_custom

.SUBCKT tiel_custom VSS VDD VOUT
M$1 VDD \$3 \$3 VDD sg13_lv_pmos L=0.13u W=0.15u AS=0.1005p AD=0.1005p PS=1.34u
+ PD=1.34u
M$2 VSS \$3 VOUT VSS sg13_lv_nmos L=0.13u W=0.15u AS=0.1005p AD=0.1005p
+ PS=1.34u PD=1.34u
.ENDS tiel_custom

.SUBCKT tg_custom VBN VOUT VSN VSP VIN VBP
M$1 VIN VSN VOUT VBN sg13_lv_nmos L=0.13u W=0.15u AS=0.1005p AD=0.1005p
+ PS=1.34u PD=1.34u
M$2 VIN VSP VOUT VBP sg13_lv_pmos L=0.13u W=0.3u AS=0.156p AD=0.156p PS=2.08u
+ PD=2.08u
.ENDS tg_custom

.SUBCKT inv VDD VIN VSS VOUT
M$1 VSS VIN VOUT VSS sg13_lv_nmos L=0.13u W=0.15u AS=0.1005p AD=0.1005p
+ PS=1.34u PD=1.34u
M$2 VDD VIN VOUT VDD sg13_lv_pmos L=0.13u W=0.15u AS=0.1005p AD=0.1005p
+ PS=1.34u PD=1.34u
.ENDS inv

.SUBCKT inv_d4 VOUT VIN VSS VDD
X$1 VIN VSS VDD VOUT inv_d2
X$2 VIN VSS VDD VOUT inv_d2
.ENDS inv_d4

.SUBCKT inv_PI_d32 VOUT VIN VSS VDD
M$1 VDD VIN VOUT VDD sg13_lv_pmos L=0.13u W=14.4u AS=6.768p AD=6.768p PS=90.24u
+ PD=90.24u
M$97 VSS VIN VOUT VSS sg13_lv_nmos L=0.13u W=9.6u AS=4.992p AD=4.992p PS=66.56u
+ PD=66.56u
.ENDS inv_PI_d32

.SUBCKT inv_PI_d4 VIN VSS VOUT VDD
X$1 VSS VIN VOUT VDD inv_PI_d2
X$2 VSS VIN VOUT VDD inv_PI_d2
.ENDS inv_PI_d4

.SUBCKT inv_d2 VIN VSS VDD VOUT
M$1 VSS VIN VOUT VSS sg13_lv_nmos L=0.13u W=0.3u AS=0.156p AD=0.156p PS=2.08u
+ PD=2.08u
M$3 VDD VIN VOUT VDD sg13_lv_pmos L=0.13u W=0.3u AS=0.156p AD=0.156p PS=2.08u
+ PD=2.08u
.ENDS inv_d2

.SUBCKT inv_PI_d2 VSS VIN VOUT VDD
X$1 VSS VIN VDD VOUT inv_PI
X$2 VSS VIN VDD VOUT inv_PI
.ENDS inv_PI_d2

.SUBCKT inv_PI VSS VIN VDD VOUT
M$1 VSS VIN VOUT VSS sg13_lv_nmos L=0.13u W=0.3u AS=0.156p AD=0.156p PS=2.08u
+ PD=2.08u
M$3 VDD VIN VOUT VDD sg13_lv_pmos L=0.13u W=0.45u AS=0.2115p AD=0.2115p
+ PS=2.82u PD=2.82u
.ENDS inv_PI
