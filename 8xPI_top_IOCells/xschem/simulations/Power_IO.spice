** sch_path: /foss/designs/IHP-Open-PDK/ihp-sg13g2/libs.tech/xschem/sg13g2_io_tests/Power_IO.sch
**.subckt Power_IO
V1 IO_vdd GND 1.2
V2 IO_iovdd GND 3.3
V3 IO_vss GND 0
V4 IO_iovss GND 0
Vc2p inp GND dc 0 ac 1 pulse(0, 1.2, 1n, 1n, 1n, 50n, 100n )
x1 IO_iovdd IO_iovss IO_vss IO_vdd sg13g2_IOPadIOVdd
x3 IO_iovdd IO_iovss IO_vss IO_vdd sg13g2_IOPadIOVss
x2 IO_iovdd IO_iovss IO_vss IO_vdd sg13g2_IOPadVSS
x4 IO_iovdd IO_iovss IO_vss IO_vdd sg13g2_IOPadVdd
x5 IO_iovdd IO_iovss out IO_vss IO_vdd inp sg13g2_IOPadIn
C1 out IO_vss 100f m=1
XX6 IO_iovss bondpad size=80u shape=0 padtype=0
XX7 IO_iovdd bondpad size=80u shape=0 padtype=0
XX8 IO_vdd bondpad size=80u shape=0 padtype=0
XX9 IO_vss bondpad size=80u shape=0 padtype=0
XX10 inp bondpad size=80u shape=0 padtype=0
XX12 Padout bondpad size=80u shape=0 padtype=0
x13 IO_iovdd IO_iovss out_a IO_vss IO_vdd in_a sg13g2_IOPadAnalog
C2 out_a IO_vss 200f m=1
XX14 in_a bondpad size=80u shape=0 padtype=0
Vc1 in_a GND dc 0 ac 0 sin(0.6, 0.5, 100meg, 1n)
V5 GND sub! 0
C3 inp IO_vss 100f m=1
V6 out_en GND 1.2
x11 IO_iovdd IO_iovss inp IO_vss IO_vdd Padout sg13g2_IOPadOut4mA
x15 IO_iovdd IO_iovss inp out_en IO_vss IO_vdd Tri_out sg13g2_IOPadTriOut16mA
XX16 Tri_out bondpad size=80u shape=0 padtype=0
C5 GND Tri_out 200f m=1
R2 Tri_out GND 50k m=1
C4 GND Padout 200f m=1
R1 Padout GND 50k m=1
**** begin user architecture code

.lib cornerMOSlv.lib mos_tt
.lib cornerMOShv.lib mos_tt
.lib cornerRES.lib res_typ
.include diodes.lib
.include sg13g2_bondpad.lib

.param temp=27
*.OPTION RSHUNT=1e6
.OPTION CSHUNT=1e-13
.option rseries = 10.0e-0
.options method=gear reltol=1e-3 abstol=1e-6
*.options gmin=1e-10
*.ic V(out)=0

.control
save all
tran  601p 180n
meas tran tdelayf TRIG v(inp) VAl=0.6 FALl=1 TARG v(out) VAl=0.6 FALL=1
meas tran tdelayr TRIG v(inp) VAl=0.6 RISE=2 TARG v(out) VAl=0.6 RISE=2
write power_io.raw

.endc

**** end user architecture code
**.ends

* expanding   symbol:  sg13g2_IOPadIOVdd.sym # of pins=4
** sym_path: /foss/designs/IHP-Open-PDK/ihp-sg13g2/libs.ref/sg13g2_io/xschem/sg13g2_IOPadIOVdd.sym
** sch_path: /foss/designs/IHP-Open-PDK/ihp-sg13g2/libs.ref/sg13g2_io/xschem/sg13g2_IOPadIOVdd.sch
.subckt sg13g2_IOPadIOVdd iovdd iovss vss vdd
*.iopin iovss
*.iopin iovdd
*.iopin vss
*.iopin vdd
x1 net2 iovdd sg13g2_RCClampResistor
x2 iovdd net1 net2 iovss sg13g2_RCClampInverter
.ends

* expanding   symbol:  sg13g2_IOPadIOVss.sym # of pins=4
** sym_path: /foss/designs/IHP-Open-PDK/ihp-sg13g2/libs.ref/sg13g2_io/xschem/sg13g2_IOPadIOVss.sym
** sch_path: /foss/designs/IHP-Open-PDK/ihp-sg13g2/libs.ref/sg13g2_io/xschem/sg13g2_IOPadIOVss.sch
.subckt sg13g2_IOPadIOVss iovdd iovss vss vdd
*.iopin iovss
*.iopin iovdd
*.iopin vdd
*.iopin vss
x8 iovss iovss iovdd sg13g2_DCNDiode
x9 iovdd iovss iovss sg13g2_DCPDiode
* noconn vdd
* noconn vss
.ends

* expanding   symbol:  sg13g2_IOPadVSS.sym # of pins=4
** sym_path: /foss/designs/IHP-Open-PDK/ihp-sg13g2/libs.ref/sg13g2_io/xschem/sg13g2_IOPadVSS.sym
** sch_path: /foss/designs/IHP-Open-PDK/ihp-sg13g2/libs.ref/sg13g2_io/xschem/sg13g2_IOPadVSS.sch
.subckt sg13g2_IOPadVSS iovdd iovss vss vdd
*.iopin iovss
*.iopin iovdd
*.iopin vss
*.iopin vdd
x1 vss iovss iovdd sg13g2_DCNDiode
x2 iovdd vss iovss sg13g2_DCPDiode
* noconn vdd
.ends

* expanding   symbol:  sg13g2_IOPadVdd.sym # of pins=4
** sym_path: /foss/designs/IHP-Open-PDK/ihp-sg13g2/libs.ref/sg13g2_io/xschem/sg13g2_IOPadVdd.sym
** sch_path: /foss/designs/IHP-Open-PDK/ihp-sg13g2/libs.ref/sg13g2_io/xschem/sg13g2_IOPadVdd.sch
.subckt sg13g2_IOPadVdd iovdd iovss vss vdd
*.iopin vdd
*.iopin iovdd
*.iopin vss
*.iopin iovss
x6 vdd net2 sg13g2_RCClampResistor
x1 vdd net1 net2 vss sg13g2_RCClampInverter
.ends

* expanding   symbol:  sg13g2_IOPadIn.sym # of pins=6
** sym_path: /foss/designs/IHP-Open-PDK/ihp-sg13g2/libs.ref/sg13g2_io/xschem/sg13g2_IOPadIn.sym
** sch_path: /foss/designs/IHP-Open-PDK/ihp-sg13g2/libs.ref/sg13g2_io/xschem/sg13g2_IOPadIn.sch
.subckt sg13g2_IOPadIn iovdd iovss p2c vss vdd pad
*.iopin iovdd
*.iopin vdd
*.iopin vss
*.iopin iovss
*.iopin p2c
*.iopin pad
x1 pad iovss iovdd sg13g2_DCNDiode
x2 iovdd pad iovss sg13g2_DCPDiode
x3 vdd iovdd p2c pad iovss vss sg13g2_LevelDown
.ends

* expanding   symbol:  sg13g2_IOPadAnalog.sym # of pins=6
** sym_path: /foss/designs/IHP-Open-PDK/ihp-sg13g2/libs.ref/sg13g2_io/xschem/sg13g2_IOPadAnalog.sym
** sch_path: /foss/designs/IHP-Open-PDK/ihp-sg13g2/libs.ref/sg13g2_io/xschem/sg13g2_IOPadAnalog.sch
.subckt sg13g2_IOPadAnalog iovdd iovss padres vss vdd pad
*.iopin padres
*.iopin iovss
*.iopin iovdd
*.iopin pad
*.iopin vdd
*.iopin vss
x3 pad iovss iovdd sg13g2_DCNDiode
x4 iovdd pad iovss sg13g2_DCPDiode
x1 pad iovdd iovss sg13g2_Clamp_N20N0D
x2 iovdd pad iovss sg13g2_Clamp_P20N0D
x5 iovdd pad padres iovss sg13g2_SecondaryProtection
.ends

* expanding   symbol:  sg13g2_IOPadOut4mA.sym # of pins=6
** sym_path: /foss/designs/IHP-Open-PDK/ihp-sg13g2/libs.ref/sg13g2_io/xschem/sg13g2_IOPadOut4mA.sym
** sch_path: /foss/designs/IHP-Open-PDK/ihp-sg13g2/libs.ref/sg13g2_io/xschem/sg13g2_IOPadOut4mA.sch
.subckt sg13g2_IOPadOut4mA iovdd iovss c2p vss vdd pad
*.iopin vdd
*.iopin vss
*.iopin iovss
*.iopin iovdd
*.iopin c2p
*.iopin pad
x1 iovdd pad net1 iovss sg13g2_Clamp_N2N2D
x2 iovdd net2 iovss pad sg13g2_Clamp_P2N2D
x5 vdd iovdd net1 net2 c2p vss sg13g2_GateLevelUpInv
x3 iovdd pad iovss sg13g2_DCPDiode
x4 pad iovss iovdd sg13g2_DCNDiode
.ends

* expanding   symbol:  sg13g2_IOPadTriOut16mA.sym # of pins=7
** sym_path: /foss/designs/IHP-Open-PDK/ihp-sg13g2/libs.ref/sg13g2_io/xschem/sg13g2_IOPadTriOut16mA.sym
** sch_path: /foss/designs/IHP-Open-PDK/ihp-sg13g2/libs.ref/sg13g2_io/xschem/sg13g2_IOPadTriOut16mA.sch
.subckt sg13g2_IOPadTriOut16mA iovdd iovss c2p c2p_en vss vdd pad
*.iopin iovss
*.iopin pad
*.iopin vss
*.iopin c2p
*.iopin vdd
*.iopin iovdd
*.iopin c2p_en
x8 pad iovss iovdd sg13g2_DCNDiode
x9 iovdd pad iovss sg13g2_DCPDiode
x1 vdd iovdd c2p_en net2 net1 c2p vss sg13g2_GateDecode
x2 iovdd pad net2 iovss sg13g2_Clamp_N8N8D
x3 iovdd net1 pad iovss sg13g2_Clamp_P8N8D
.ends

* expanding   symbol:  sg13g2_RCClampResistor.sym # of pins=2
** sym_path: /foss/designs/IHP-Open-PDK/ihp-sg13g2/libs.ref/sg13g2_io/xschem/sg13g2_RCClampResistor.sym
** sch_path: /foss/designs/IHP-Open-PDK/ihp-sg13g2/libs.ref/sg13g2_io/xschem/sg13g2_RCClampResistor.sch
.subckt sg13g2_RCClampResistor pin2 pin1
*.iopin pin1
*.iopin pin2
XR1 pin1 net1 sub! rppd w=1.0e-6 l=20.0e-6 m=1 b=0
XR2 net1 net2 sub! rppd w=1.0e-6 l=20.0e-6 m=1 b=0
XR3 net2 net3 sub! rppd w=1.0e-6 l=20.0e-6 m=1 b=0
XR4 net3 net4 sub! rppd w=1.0e-6 l=20.0e-6 m=1 b=0
XR5 net8 net7 sub! rppd w=1.0e-6 l=20.0e-6 m=1 b=0
XR6 net7 net6 sub! rppd w=1.0e-6 l=20.0e-6 m=1 b=0
XR7 net6 net5 sub! rppd w=1.0e-6 l=20.0e-6 m=1 b=0
XR8 net5 net4 sub! rppd w=1.0e-6 l=20.0e-6 m=1 b=0
XR9 net8 net9 sub! rppd w=1.0e-6 l=20.0e-6 m=1 b=0
XR10 net9 net10 sub! rppd w=1.0e-6 l=20.0e-6 m=1 b=0
XR11 net10 net11 sub! rppd w=1.0e-6 l=20.0e-6 m=1 b=0
XR12 net11 net12 sub! rppd w=1.0e-6 l=20.0e-6 m=1 b=0
XR13 net16 net15 sub! rppd w=1.0e-6 l=20.0e-6 m=1 b=0
XR14 net15 net14 sub! rppd w=1.0e-6 l=20.0e-6 m=1 b=0
XR15 net14 net13 sub! rppd w=1.0e-6 l=20.0e-6 m=1 b=0
XR16 net13 net12 sub! rppd w=1.0e-6 l=20.0e-6 m=1 b=0
XR17 net16 net17 sub! rppd w=1.0e-6 l=20.0e-6 m=1 b=0
XR18 net17 net18 sub! rppd w=1.0e-6 l=20.0e-6 m=1 b=0
XR19 net18 net19 sub! rppd w=1.0e-6 l=20.0e-6 m=1 b=0
XR20 net19 net20 sub! rppd w=1.0e-6 l=20.0e-6 m=1 b=0
XR21 net24 net23 sub! rppd w=1.0e-6 l=20.0e-6 m=1 b=0
XR22 net23 net22 sub! rppd w=1.0e-6 l=20.0e-6 m=1 b=0
XR23 net22 net21 sub! rppd w=1.0e-6 l=20.0e-6 m=1 b=0
XR24 net21 net20 sub! rppd w=1.0e-6 l=20.0e-6 m=1 b=0
XR25 net24 net25 sub! rppd w=1.0e-6 l=20.0e-6 m=1 b=0
XR26 net25 pin2 sub! rppd w=1.0e-6 l=20.0e-6 m=1 b=0
.ends

* expanding   symbol:  sg13g2_RCClampInverter.sym # of pins=4
** sym_path: /foss/designs/IHP-Open-PDK/ihp-sg13g2/libs.ref/sg13g2_io/xschem/sg13g2_RCClampInverter.sym
** sch_path: /foss/designs/IHP-Open-PDK/ihp-sg13g2/libs.ref/sg13g2_io/xschem/sg13g2_RCClampInverter.sch
.subckt sg13g2_RCClampInverter supply out in ground
*.iopin supply
*.iopin ground
*.opin out
*.ipin in
XM1 ground in ground ground sg13_hv_nmos w=9.0u l=9.5u ng=1 m=1
XM2 ground in ground ground sg13_hv_nmos w=9.0u l=9.5u ng=1 m=1
XM3 ground in ground ground sg13_hv_nmos w=9.0u l=9.5u ng=1 m=1
XM4 ground in ground ground sg13_hv_nmos w=9.0u l=9.5u ng=1 m=1
XM5 ground in ground ground sg13_hv_nmos w=9.0u l=9.5u ng=1 m=1
XM6 ground in ground ground sg13_hv_nmos w=9.0u l=9.5u ng=1 m=1
XM7 ground in ground ground sg13_hv_nmos w=9.0u l=9.5u ng=1 m=1
XM8 ground in ground ground sg13_hv_nmos w=9.0u l=9.5u ng=1 m=1
XM9 ground in ground ground sg13_hv_nmos w=9.0u l=9.5u ng=1 m=1
XM10 ground in ground ground sg13_hv_nmos w=9.0u l=9.5u ng=1 m=1
XM11 ground in ground ground sg13_hv_nmos w=9.0u l=9.5u ng=1 m=1
XM12 ground in ground ground sg13_hv_nmos w=9.0u l=9.5u ng=1 m=1
XM13 ground in ground ground sg13_hv_nmos w=9.0u l=9.5u ng=1 m=1
XM14 ground in ground ground sg13_hv_nmos w=9.0u l=9.5u ng=1 m=1
XM15 out in ground ground sg13_hv_nmos w=9.0u l=0.5u ng=1 m=1
XM16 out in ground ground sg13_hv_nmos w=9.0u l=0.5u ng=1 m=1
XM17 out in ground ground sg13_hv_nmos w=9.0u l=0.5u ng=1 m=1
XM18 out in ground ground sg13_hv_nmos w=9.0u l=0.5u ng=1 m=1
XM19 out in ground ground sg13_hv_nmos w=9.0u l=0.5u ng=1 m=1
XM20 out in ground ground sg13_hv_nmos w=9.0u l=0.5u ng=1 m=1
XM21 out in ground ground sg13_hv_nmos w=9.0u l=0.5u ng=1 m=1
XM22 out in ground ground sg13_hv_nmos w=9.0u l=0.5u ng=1 m=1
XM23 out in ground ground sg13_hv_nmos w=9.0u l=0.5u ng=1 m=1
XM24 out in ground ground sg13_hv_nmos w=9.0u l=0.5u ng=1 m=1
XM25 out in ground ground sg13_hv_nmos w=9.0u l=0.5u ng=1 m=1
XM26 out in ground ground sg13_hv_nmos w=9.0u l=0.5u ng=1 m=1
XM27 out in supply supply sg13_hv_pmos w=7.0u l=0.5u ng=1 m=1
XM28 out in supply supply sg13_hv_pmos w=7.0u l=0.5u ng=1 m=1
XM29 out in supply supply sg13_hv_pmos w=7.0u l=0.5u ng=1 m=1
XM30 out in supply supply sg13_hv_pmos w=7.0u l=0.5u ng=1 m=1
XM31 out in supply supply sg13_hv_pmos w=7.0u l=0.5u ng=1 m=1
XM32 out in supply supply sg13_hv_pmos w=7.0u l=0.5u ng=1 m=1
XM33 out in supply supply sg13_hv_pmos w=7.0u l=0.5u ng=1 m=1
XM34 out in supply supply sg13_hv_pmos w=7.0u l=0.5u ng=1 m=1
XM35 out in supply supply sg13_hv_pmos w=7.0u l=0.5u ng=1 m=1
XM36 out in supply supply sg13_hv_pmos w=7.0u l=0.5u ng=1 m=1
XM37 out in supply supply sg13_hv_pmos w=7.0u l=0.5u ng=1 m=1
XM38 out in supply supply sg13_hv_pmos w=7.0u l=0.5u ng=1 m=1
XM39 out in supply supply sg13_hv_pmos w=7.0u l=0.5u ng=1 m=1
XM40 out in supply supply sg13_hv_pmos w=7.0u l=0.5u ng=1 m=1
XM41 out in supply supply sg13_hv_pmos w=7.0u l=0.5u ng=1 m=1
XM42 out in supply supply sg13_hv_pmos w=7.0u l=0.5u ng=1 m=1
XM43 out in supply supply sg13_hv_pmos w=7.0u l=0.5u ng=1 m=1
XM44 out in supply supply sg13_hv_pmos w=7.0u l=0.5u ng=1 m=1
XM45 out in supply supply sg13_hv_pmos w=7.0u l=0.5u ng=1 m=1
XM46 out in supply supply sg13_hv_pmos w=7.0u l=0.5u ng=1 m=1
XM47 out in supply supply sg13_hv_pmos w=7.0u l=0.5u ng=1 m=1
XM48 out in supply supply sg13_hv_pmos w=7.0u l=0.5u ng=1 m=1
XM49 out in supply supply sg13_hv_pmos w=7.0u l=0.5u ng=1 m=1
XM50 out in supply supply sg13_hv_pmos w=7.0u l=0.5u ng=1 m=1
XM51 out in supply supply sg13_hv_pmos w=7.0u l=0.5u ng=1 m=1
XM52 out in supply supply sg13_hv_pmos w=7.0u l=0.5u ng=1 m=1
XM53 out in supply supply sg13_hv_pmos w=7.0u l=0.5u ng=1 m=1
XM54 out in supply supply sg13_hv_pmos w=7.0u l=0.5u ng=1 m=1
XM55 out in supply supply sg13_hv_pmos w=7.0u l=0.5u ng=1 m=1
XM56 out in supply supply sg13_hv_pmos w=7.0u l=0.5u ng=1 m=1
XM57 out in supply supply sg13_hv_pmos w=7.0u l=0.5u ng=1 m=1
XM58 out in supply supply sg13_hv_pmos w=7.0u l=0.5u ng=1 m=1
XM59 out in supply supply sg13_hv_pmos w=7.0u l=0.5u ng=1 m=1
XM60 out in supply supply sg13_hv_pmos w=7.0u l=0.5u ng=1 m=1
XM61 out in supply supply sg13_hv_pmos w=7.0u l=0.5u ng=1 m=1
XM62 out in supply supply sg13_hv_pmos w=7.0u l=0.5u ng=1 m=1
XM63 out in supply supply sg13_hv_pmos w=7.0u l=0.5u ng=1 m=1
XM64 out in supply supply sg13_hv_pmos w=7.0u l=0.5u ng=1 m=1
XM65 out in supply supply sg13_hv_pmos w=7.0u l=0.5u ng=1 m=1
XM66 out in supply supply sg13_hv_pmos w=7.0u l=0.5u ng=1 m=1
XM67 out in supply supply sg13_hv_pmos w=7.0u l=0.5u ng=1 m=1
XM68 out in supply supply sg13_hv_pmos w=7.0u l=0.5u ng=1 m=1
XM69 out in supply supply sg13_hv_pmos w=7.0u l=0.5u ng=1 m=1
XM70 out in supply supply sg13_hv_pmos w=7.0u l=0.5u ng=1 m=1
XM71 out in supply supply sg13_hv_pmos w=7.0u l=0.5u ng=1 m=1
XM72 out in supply supply sg13_hv_pmos w=7.0u l=0.5u ng=1 m=1
XM73 out in supply supply sg13_hv_pmos w=7.0u l=0.5u ng=1 m=1
XM74 net1 in supply supply sg13_hv_pmos w=7.0u l=0.5u ng=1 m=1
XM75 out in supply supply sg13_hv_pmos w=7.0u l=0.5u ng=1 m=1
XM76 out in supply supply sg13_hv_pmos w=7.0u l=0.5u ng=1 m=1
.ends

* expanding   symbol:  sg13g2_DCNDiode.sym # of pins=3
** sym_path: /foss/designs/IHP-Open-PDK/ihp-sg13g2/libs.ref/sg13g2_io/xschem/sg13g2_DCNDiode.sym
** sch_path: /foss/designs/IHP-Open-PDK/ihp-sg13g2/libs.ref/sg13g2_io/xschem/sg13g2_DCNDiode.sch
.subckt sg13g2_DCNDiode cathode anode guard
*.iopin cathode
*.iopin anode
*.iopin guard
XD1 anode cathode dantenna l=1.26u w=27.78u
XD2 anode cathode dantenna l=1.26u w=27.78u
* noconn guard
.ends

* expanding   symbol:  sg13g2_DCPDiode.sym # of pins=3
** sym_path: /foss/designs/IHP-Open-PDK/ihp-sg13g2/libs.ref/sg13g2_io/xschem/sg13g2_DCPDiode.sym
** sch_path: /foss/designs/IHP-Open-PDK/ihp-sg13g2/libs.ref/sg13g2_io/xschem/sg13g2_DCPDiode.sch
.subckt sg13g2_DCPDiode cathode anode guard
*.iopin cathode
*.iopin anode
*.iopin guard
XD1 anode cathode dpantenna l=1.26u w=27.78u
XD2 anode cathode dpantenna l=1.26u w=27.78u
* noconn guard
.ends

* expanding   symbol:  sg13g2_LevelDown.sym # of pins=6
** sym_path: /foss/designs/IHP-Open-PDK/ihp-sg13g2/libs.ref/sg13g2_io/xschem/sg13g2_LevelDown.sym
** sch_path: /foss/designs/IHP-Open-PDK/ihp-sg13g2/libs.ref/sg13g2_io/xschem/sg13g2_LevelDown.sch
.subckt sg13g2_LevelDown vdd iovdd core pad iovss vss
*.iopin vdd
*.iopin vss
*.iopin iovdd
*.iopin iovss
*.iopin pad
*.iopin core
XM1 vss net2 net1 vss sg13_hv_nmos w=2.65u l=0.45u ng=1 m=1
XM2 net1 net2 vdd vdd sg13_hv_pmos w=4.65u l=0.45u ng=1 m=1
XM3 vss net1 core vss sg13_lv_nmos w=2.75u l=0.13u ng=1 m=1
XM4 core net1 vdd vdd sg13_lv_pmos w=4.75u l=0.13u ng=1 m=1
x1 iovdd pad net2 iovss sg13g2_SecondaryProtection
.ends

* expanding   symbol:  sg13g2_Clamp_N20N0D.sym # of pins=3
** sym_path: /foss/designs/IHP-Open-PDK/ihp-sg13g2/libs.ref/sg13g2_io/xschem/sg13g2_Clamp_N20N0D.sym
** sch_path: /foss/designs/IHP-Open-PDK/ihp-sg13g2/libs.ref/sg13g2_io/xschem/sg13g2_Clamp_N20N0D.sch
.subckt sg13g2_Clamp_N20N0D pad iovdd iovss
*.iopin iovss
*.iopin pad
*.iopin iovdd
XM1 iovss net1 pad iovss sg13_hv_nmos w=4.4u l=0.6u ng=1 m=1
XM2 pad net1 iovss iovss sg13_hv_nmos w=4.4u l=0.6u ng=1 m=1
XM3 iovss net1 pad iovss sg13_hv_nmos w=4.4u l=0.6u ng=1 m=1
XM4 pad net1 iovss iovss sg13_hv_nmos w=4.4u l=0.6u ng=1 m=1
XM5 iovss net1 pad iovss sg13_hv_nmos w=4.4u l=0.6u ng=1 m=1
XM6 pad net1 iovss iovss sg13_hv_nmos w=4.4u l=0.6u ng=1 m=1
XM7 iovss net1 pad iovss sg13_hv_nmos w=4.4u l=0.6u ng=1 m=1
XM8 pad net1 iovss iovss sg13_hv_nmos w=4.4u l=0.6u ng=1 m=1
XM9 iovss net1 pad iovss sg13_hv_nmos w=4.4u l=0.6u ng=1 m=1
XM10 pad net1 iovss iovss sg13_hv_nmos w=4.4u l=0.6u ng=1 m=1
XM11 iovss net1 pad iovss sg13_hv_nmos w=4.4u l=0.6u ng=1 m=1
XM12 pad net1 iovss iovss sg13_hv_nmos w=4.4u l=0.6u ng=1 m=1
XM13 iovss net1 pad iovss sg13_hv_nmos w=4.4u l=0.6u ng=1 m=1
XM14 pad net1 iovss iovss sg13_hv_nmos w=4.4u l=0.6u ng=1 m=1
XM15 iovss net1 pad iovss sg13_hv_nmos w=4.4u l=0.6u ng=1 m=1
XM16 iovss net1 pad iovss sg13_hv_nmos w=4.4u l=0.6u ng=1 m=1
XM17 pad net1 iovss iovss sg13_hv_nmos w=4.4u l=0.6u ng=1 m=1
XM18 iovss net1 pad iovss sg13_hv_nmos w=4.4u l=0.6u ng=1 m=1
XM19 pad net1 iovss iovss sg13_hv_nmos w=4.4u l=0.6u ng=1 m=1
XM20 iovss net1 pad iovss sg13_hv_nmos w=4.4u l=0.6u ng=1 m=1
XR1 iovss net1 sub! rppd w=0.5e-6 l=0.5e-6 m=1 b=0
.ends

* expanding   symbol:  sg13g2_Clamp_P20N0D.sym # of pins=3
** sym_path: /foss/designs/IHP-Open-PDK/ihp-sg13g2/libs.ref/sg13g2_io/xschem/sg13g2_Clamp_P20N0D.sym
** sch_path: /foss/designs/IHP-Open-PDK/ihp-sg13g2/libs.ref/sg13g2_io/xschem/sg13g2_Clamp_P20N0D.sch
.subckt sg13g2_Clamp_P20N0D iovdd pad iovss
*.iopin iovdd
*.iopin pad
*.iopin iovss
XM1 pad net1 iovdd iovdd sg13_hv_pmos w=6.66u l=0.6u ng=1 m=1
XM2 iovdd net1 pad iovdd sg13_hv_pmos w=6.66u l=0.6u ng=1 m=1
XM3 pad net1 iovdd iovdd sg13_hv_pmos w=6.66u l=0.6u ng=1 m=1
XM4 iovdd net1 pad iovdd sg13_hv_pmos w=6.66u l=0.6u ng=1 m=1
XM5 pad net1 iovdd iovdd sg13_hv_pmos w=6.66u l=0.6u ng=1 m=1
XM6 iovdd net1 pad iovdd sg13_hv_pmos w=6.66u l=0.6u ng=1 m=1
XM7 pad net1 iovdd iovdd sg13_hv_pmos w=6.66u l=0.6u ng=1 m=1
XM8 iovdd net1 pad iovdd sg13_hv_pmos w=6.66u l=0.6u ng=1 m=1
XM9 pad net1 iovdd iovdd sg13_hv_pmos w=6.66u l=0.6u ng=1 m=1
XM10 iovdd net1 pad iovdd sg13_hv_pmos w=6.66u l=0.6u ng=1 m=1
XM11 pad net1 iovdd iovdd sg13_hv_pmos w=6.66u l=0.6u ng=1 m=1
XM12 iovdd net1 pad iovdd sg13_hv_pmos w=6.66u l=0.6u ng=1 m=1
XM13 pad net1 iovdd iovdd sg13_hv_pmos w=6.66u l=0.6u ng=1 m=1
XM14 iovdd net1 pad iovdd sg13_hv_pmos w=6.66u l=0.6u ng=1 m=1
XM15 pad net1 iovdd iovdd sg13_hv_pmos w=6.66u l=0.6u ng=1 m=1
XM16 iovdd net1 pad iovdd sg13_hv_pmos w=6.66u l=0.6u ng=1 m=1
XM17 pad net1 iovdd iovdd sg13_hv_pmos w=6.66u l=0.6u ng=1 m=1
XM18 iovdd net1 pad iovdd sg13_hv_pmos w=6.66u l=0.6u ng=1 m=1
XM19 pad net1 iovdd iovdd sg13_hv_pmos w=6.66u l=0.6u ng=1 m=1
XM20 iovdd net1 pad iovdd sg13_hv_pmos w=6.66u l=0.6u ng=1 m=1
XM21 pad net1 iovdd iovdd sg13_hv_pmos w=6.66u l=0.6u ng=1 m=1
XM22 iovdd net1 pad iovdd sg13_hv_pmos w=6.66u l=0.6u ng=1 m=1
XM23 pad net1 iovdd iovdd sg13_hv_pmos w=6.66u l=0.6u ng=1 m=1
XM24 iovdd net1 pad iovdd sg13_hv_pmos w=6.66u l=0.6u ng=1 m=1
XM25 pad net1 iovdd iovdd sg13_hv_pmos w=6.66u l=0.6u ng=1 m=1
XM26 iovdd net1 pad iovdd sg13_hv_pmos w=6.66u l=0.6u ng=1 m=1
XM27 pad net1 iovdd iovdd sg13_hv_pmos w=6.66u l=0.6u ng=1 m=1
XM28 iovdd net1 pad iovdd sg13_hv_pmos w=6.66u l=0.6u ng=1 m=1
XM29 pad net1 iovdd iovdd sg13_hv_pmos w=6.66u l=0.6u ng=1 m=1
XM30 iovdd net1 pad iovdd sg13_hv_pmos w=6.66u l=0.6u ng=1 m=1
XM31 pad net1 iovdd iovdd sg13_hv_pmos w=6.66u l=0.6u ng=1 m=1
XM32 iovdd net1 pad iovdd sg13_hv_pmos w=6.66u l=0.6u ng=1 m=1
XM33 pad net1 iovdd iovdd sg13_hv_pmos w=6.66u l=0.6u ng=1 m=1
XM34 iovdd net1 pad iovdd sg13_hv_pmos w=6.66u l=0.6u ng=1 m=1
XM35 pad net1 iovdd iovdd sg13_hv_pmos w=6.66u l=0.6u ng=1 m=1
XM36 iovdd net1 pad iovdd sg13_hv_pmos w=6.66u l=0.6u ng=1 m=1
XM37 pad net1 iovdd iovdd sg13_hv_pmos w=6.66u l=0.6u ng=1 m=1
XM38 iovdd net1 pad iovdd sg13_hv_pmos w=6.66u l=0.6u ng=1 m=1
XM39 pad net1 iovdd iovdd sg13_hv_pmos w=6.66u l=0.6u ng=1 m=1
XM40 iovdd net1 pad iovdd sg13_hv_pmos w=6.66u l=0.6u ng=1 m=1
XR1 net1 iovdd sub! rppd w=0.5e-6 l=12.9e-6 m=1 b=0
.ends

* expanding   symbol:  sg13g2_SecondaryProtection.sym # of pins=4
** sym_path: /foss/designs/IHP-Open-PDK/ihp-sg13g2/libs.ref/sg13g2_io/xschem/sg13g2_SecondaryProtection.sym
** sch_path: /foss/designs/IHP-Open-PDK/ihp-sg13g2/libs.ref/sg13g2_io/xschem/sg13g2_SecondaryProtection.sch
.subckt sg13g2_SecondaryProtection iovdd pad core iovss
*.iopin iovdd
*.iopin iovss
*.iopin core
*.iopin pad
XR1 pad core sub! rppd w=1e-6 l=2e-6 m=1 b=0
XD1 iovss core dantenna l=3.1u w=0.78u
XD2 core iovdd dpantenna l=0.78u w=4.98u
.ends

* expanding   symbol:  sg13g2_Clamp_N2N2D.sym # of pins=4
** sym_path: /foss/designs/IHP-Open-PDK/ihp-sg13g2/libs.ref/sg13g2_io/xschem/sg13g2_Clamp_N2N2D.sym
** sch_path: /foss/designs/IHP-Open-PDK/ihp-sg13g2/libs.ref/sg13g2_io/xschem/sg13g2_Clamp_N2N2D.sch
.subckt sg13g2_Clamp_N2N2D iovdd pad gate iovss
*.iopin iovss
*.iopin gate
*.iopin pad
*.iopin iovdd
XM1 pad gate iovss iovss sg13_hv_nmos w=4.4u l=0.6u ng=1 m=1
XM2 pad gate iovss iovss sg13_hv_nmos w=4.4u l=0.6u ng=1 m=1
.ends

* expanding   symbol:  sg13g2_Clamp_P2N2D.sym # of pins=4
** sym_path: /foss/designs/IHP-Open-PDK/ihp-sg13g2/libs.ref/sg13g2_io/xschem/sg13g2_Clamp_P2N2D.sym
** sch_path: /foss/designs/IHP-Open-PDK/ihp-sg13g2/libs.ref/sg13g2_io/xschem/sg13g2_Clamp_P2N2D.sch
.subckt sg13g2_Clamp_P2N2D iovdd gate iovss pad
*.iopin pad
*.iopin iovdd
*.iopin gate
*.iopin iovss
XM1 pad gate iovdd iovdd sg13_hv_pmos w=6.66u l=0.6u ng=1 m=1
XM2 pad gate iovdd iovdd sg13_hv_pmos w=6.66u l=0.6u ng=1 m=1
XM3 pad gate iovdd iovdd sg13_hv_pmos w=6.66u l=0.6u ng=1 m=1
XM4 pad gate iovdd iovdd sg13_hv_pmos w=6.66u l=0.6u ng=1 m=1
.ends

* expanding   symbol:  sg13g2_GateLevelUpInv.sym # of pins=6
** sym_path: /foss/designs/IHP-Open-PDK/ihp-sg13g2/libs.ref/sg13g2_io/xschem/sg13g2_GateLevelUpInv.sym
** sch_path: /foss/designs/IHP-Open-PDK/ihp-sg13g2/libs.ref/sg13g2_io/xschem/sg13g2_GateLevelUpInv.sch
.subckt sg13g2_GateLevelUpInv vdd iovdd ngate pgate core vss
*.iopin vdd
*.iopin iovdd
*.iopin core
*.iopin vss
*.iopin pgate
*.iopin ngate
x1 iovdd vdd ngate core vss sg13g2_LevelUpInv
x2 iovdd vdd pgate core vss sg13g2_LevelUpInv
.ends

* expanding   symbol:  sg13g2_GateDecode.sym # of pins=7
** sym_path: /foss/designs/IHP-Open-PDK/ihp-sg13g2/libs.ref/sg13g2_io/xschem/sg13g2_GateDecode.sym
** sch_path: /foss/designs/IHP-Open-PDK/ihp-sg13g2/libs.ref/sg13g2_io/xschem/sg13g2_GateDecode.sch
.subckt sg13g2_GateDecode vdd iovdd en ngate pgate core vss
*.ipin en
*.ipin core
*.iopin vss
*.iopin vdd
*.iopin iovdd
*.opin ngate
*.opin pgate
x1 vdd en net1 vss sg13g2_io_inv_x1
x2 vdd core net2 net1 vss sg13g2_io_nor2_x1
x3 iovdd vdd net3 pgate vss sg13g2_LevelUp
x4 vdd net3 en core vss sg13g2_io_nand2_x1
x5 iovdd vdd net2 ngate vss sg13g2_LevelUp
.ends

* expanding   symbol:  sg13g2_Clamp_N8N8D.sym # of pins=4
** sym_path: /foss/designs/IHP-Open-PDK/ihp-sg13g2/libs.ref/sg13g2_io/xschem/sg13g2_Clamp_N8N8D.sym
** sch_path: /foss/designs/IHP-Open-PDK/ihp-sg13g2/libs.ref/sg13g2_io/xschem/sg13g2_Clamp_N8N8D.sch
.subckt sg13g2_Clamp_N8N8D iovdd pad gate iovss
*.iopin iovss
*.iopin pad
*.iopin gate
*.iopin iovdd
XM1 pad gate iovss iovss sg13_hv_nmos w=4.4u l=0.6u ng=1 m=1
XM2 pad gate iovss iovss sg13_hv_nmos w=4.4u l=0.6u ng=1 m=1
XM3 pad gate iovss iovss sg13_hv_nmos w=4.4u l=0.6u ng=1 m=1
XM4 pad gate iovss iovss sg13_hv_nmos w=4.4u l=0.6u ng=1 m=1
XM5 pad gate iovss iovss sg13_hv_nmos w=4.4u l=0.6u ng=1 m=1
XM6 pad gate iovss iovss sg13_hv_nmos w=4.4u l=0.6u ng=1 m=1
XM7 pad gate iovss iovss sg13_hv_nmos w=4.4u l=0.6u ng=1 m=1
XM8 pad gate iovss iovss sg13_hv_nmos w=4.4u l=0.6u ng=1 m=1
XD1 iovss gate dantenna l=0.64u w=0.3u
.ends

* expanding   symbol:  sg13g2_Clamp_P8N8D.sym # of pins=4
** sym_path: /foss/designs/IHP-Open-PDK/ihp-sg13g2/libs.ref/sg13g2_io/xschem/sg13g2_Clamp_P8N8D.sym
** sch_path: /foss/designs/IHP-Open-PDK/ihp-sg13g2/libs.ref/sg13g2_io/xschem/sg13g2_Clamp_P8N8D.sch
.subckt sg13g2_Clamp_P8N8D iovdd gate pad iovss
*.iopin iovdd
*.iopin gate
*.iopin pad
*.iopin iovss
XM1 pad gate iovdd iovdd sg13_hv_pmos w=6.66u l=0.6u ng=1 m=1
XM2 pad gate iovdd iovdd sg13_hv_pmos w=6.66u l=0.6u ng=1 m=1
XM3 pad gate iovdd iovdd sg13_hv_pmos w=6.66u l=0.6u ng=1 m=1
XM4 pad gate iovdd iovdd sg13_hv_pmos w=6.66u l=0.6u ng=1 m=1
XM5 pad gate iovdd iovdd sg13_hv_pmos w=6.66u l=0.6u ng=1 m=1
XM6 pad gate iovdd iovdd sg13_hv_pmos w=6.66u l=0.6u ng=1 m=1
XM7 pad gate iovdd iovdd sg13_hv_pmos w=6.66u l=0.6u ng=1 m=1
XM8 pad gate iovdd iovdd sg13_hv_pmos w=6.66u l=0.6u ng=1 m=1
XM9 pad gate iovdd iovdd sg13_hv_pmos w=6.66u l=0.6u ng=1 m=1
XM10 pad gate iovdd iovdd sg13_hv_pmos w=6.66u l=0.6u ng=1 m=1
XM11 pad gate iovdd iovdd sg13_hv_pmos w=6.66u l=0.6u ng=1 m=1
XM12 pad gate iovdd iovdd sg13_hv_pmos w=6.66u l=0.6u ng=1 m=1
XM13 pad gate iovdd iovdd sg13_hv_pmos w=6.66u l=0.6u ng=1 m=1
XM14 pad gate iovdd iovdd sg13_hv_pmos w=6.66u l=0.6u ng=1 m=1
XM15 pad gate iovdd iovdd sg13_hv_pmos w=6.66u l=0.6u ng=1 m=1
XM16 pad gate iovdd iovdd sg13_hv_pmos w=6.66u l=0.6u ng=1 m=1
XD1 gate iovdd dpantenna l=0.64u w=0.3u
.ends

* expanding   symbol:  sg13g2_LevelUpInv.sym # of pins=5
** sym_path: /foss/designs/IHP-Open-PDK/ihp-sg13g2/libs.ref/sg13g2_io/xschem/sg13g2_LevelUpInv.sym
** sch_path: /foss/designs/IHP-Open-PDK/ihp-sg13g2/libs.ref/sg13g2_io/xschem/sg13g2_LevelUpInv.sch
.subckt sg13g2_LevelUpInv iovdd vdd o i vss
*.iopin i
*.iopin vss
*.iopin vdd
*.iopin iovdd
*.iopin o
XM1 net1 i vss vss sg13_lv_nmos w=2.75u l=0.13u ng=1 m=1
XM2 net1 i vdd vdd sg13_lv_pmos w=4.75u l=0.13u ng=1 m=1
XM3 net2 net1 vss vss sg13_hv_nmos w=1.9u l=0.45u ng=1 m=1
XM4 net3 i vss vss sg13_hv_nmos w=1.9u l=0.45u ng=1 m=1
XM5 net2 net3 iovdd iovdd sg13_hv_pmos w=0.3u l=0.45u ng=1 m=1
XM6 net3 net2 iovdd iovdd sg13_hv_pmos w=0.3u l=0.45u ng=1 m=1
XM7 o net2 vss vss sg13_hv_nmos w=1.9u l=0.45u ng=1 m=1
XM8 o net2 iovdd iovdd sg13_hv_pmos w=3.9u l=0.45u ng=1 m=1
.ends

* expanding   symbol:  sg13g2_io_inv_x1.sym # of pins=4
** sym_path: /foss/designs/IHP-Open-PDK/ihp-sg13g2/libs.ref/sg13g2_io/xschem/sg13g2_io_inv_x1.sym
** sch_path: /foss/designs/IHP-Open-PDK/ihp-sg13g2/libs.ref/sg13g2_io/xschem/sg13g2_io_inv_x1.sch
.subckt sg13g2_io_inv_x1 vdd i nq vss
*.ipin i
*.iopin vdd
*.iopin vss
*.opin nq
XM2 nq i vdd vdd sg13_lv_pmos w=4.41u l=0.13u ng=1 m=1
XM1 nq i vss vss sg13_lv_nmos w=3.93u l=0.13u ng=1 m=1
.ends

* expanding   symbol:  sg13g2_io_nor2_x1.sym # of pins=5
** sym_path: /foss/designs/IHP-Open-PDK/ihp-sg13g2/libs.ref/sg13g2_io/xschem/sg13g2_io_nor2_x1.sym
** sch_path: /foss/designs/IHP-Open-PDK/ihp-sg13g2/libs.ref/sg13g2_io/xschem/sg13g2_io_nor2_x1.sch
.subckt sg13g2_io_nor2_x1 vdd i0 nq i1 vss
*.iopin vss
*.iopin vdd
*.ipin i0
*.ipin i1
*.opin nq
XM1 vss i1 nq vss sg13_lv_nmos w=3.93u l=0.13u ng=1 m=1
XM2 net1 i1 vdd vdd sg13_lv_pmos w=4.41u l=0.13u ng=1 m=1
XM3 vss i0 nq vss sg13_lv_nmos w=3.93u l=0.13u ng=1 m=1
XM4 nq i0 net1 vdd sg13_lv_pmos w=4.41u l=0.13u ng=1 m=1
.ends

* expanding   symbol:  sg13g2_LevelUp.sym # of pins=5
** sym_path: /foss/designs/IHP-Open-PDK/ihp-sg13g2/libs.ref/sg13g2_io/xschem/sg13g2_LevelUp.sym
** sch_path: /foss/designs/IHP-Open-PDK/ihp-sg13g2/libs.ref/sg13g2_io/xschem/sg13g2_LevelUp.sch
.subckt sg13g2_LevelUp iovdd vdd i o vss
*.iopin vss
*.iopin iovdd
*.iopin vdd
*.ipin i
*.opin o
XM1 vss i i_n vss sg13_lv_nmos w=2.75u l=0.13u ng=1 m=1
XM2 i_n i vdd vdd sg13_lv_pmos w=4.75u l=0.13u ng=1 m=1
XM3 lvld i_n vss vss sg13_hv_nmos w=1.9u l=0.45u ng=1 m=1
XM4 lvld_n i vss vss sg13_hv_nmos w=1.9u l=0.45u ng=1 m=1
XM5 o lvld_n vss vss sg13_hv_nmos w=1.9u l=0.45u ng=1 m=1
XM6 lvld lvld_n iovdd iovdd sg13_hv_pmos w=0.3u l=0.45u ng=1 m=1
XM7 lvld_n lvld iovdd iovdd sg13_hv_pmos w=0.3u l=0.45u ng=1 m=1
XM8 o lvld_n iovdd iovdd sg13_hv_pmos w=3.9u l=0.45u ng=1 m=1
.ends

* expanding   symbol:  sg13g2_io_nand2_x1.sym # of pins=5
** sym_path: /foss/designs/IHP-Open-PDK/ihp-sg13g2/libs.ref/sg13g2_io/xschem/sg13g2_io_nand2_x1.sym
** sch_path: /foss/designs/IHP-Open-PDK/ihp-sg13g2/libs.ref/sg13g2_io/xschem/sg13g2_io_nand2_x1.sch
.subckt sg13g2_io_nand2_x1 vdd nq i1 i0 vss
*.iopin vdd
*.iopin vss
*.ipin i0
*.ipin i1
*.opin nq
XM2 nq i1 vdd vdd sg13_lv_pmos w=4.41u l=0.13u ng=1 m=1
XM3 net1 i1 nq vss sg13_lv_nmos w=3.93u l=0.13u ng=1 m=1
XM4 vss i0 net1 vss sg13_lv_nmos w=3.93u l=0.13u ng=1 m=1
XM5 nq i0 vdd vdd sg13_lv_pmos w=4.41u l=0.13u ng=1 m=1
.ends

.GLOBAL GND
.GLOBAL sub!
.end
