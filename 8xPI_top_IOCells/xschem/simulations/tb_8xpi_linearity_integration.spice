** sch_path: /foss/designs/IHP-Open-PDK/ihp-sg13g2/libs.ref/sg13g2_io/xschem/tb_8xpi_linearity_integration.sch
**.subckt tb_8xpi_linearity_integration
x1 IO_vdd pv4 pv3 pv2 pv1 pv0 vinI vinIB vout net1 IO_vss 8xPI_top
Vin3 vinI GND dc 0 ac 0 pulse(0, 1.2, 0, 50p, 50p, 200p, 500p)
Vin5 vinIB GND dc 0 ac 0 pulse(0, 1.2, 250p, 50p, 50p, 200p, 500p )
Vdd9 iv1 IO_vss dc 0 ac 0 pulse(0, 1.2, 5n,{SR_control},{SR_control}, 5n, 10n)
Vdd10 iv2 IO_vss dc 0 ac 0 pulse(0, 1.2, 10n,{SR_control},{SR_control}, 10n, 20n)
Vdd11 iv0 IO_vss dc 0 ac 0 pulse(0, 1.2, 2.5n,{SR_control},{SR_control}, 2.5n, 5n)
Vdd1 iv3 IO_vss dc 0 ac 0 pulse(0, 1.2, 20n,{SR_control},{SR_control}, 20n, 40n)
Vdd2 iv4 IO_vss dc 0 ac 0 pulse(0, 1.2, 40n,{SR_control},{SR_control}, 40n, 80n)
Vdd4 vcont GND 0.9
x3 IO_iovdd IO_iovss IO_vss IO_vdd sg13g2_IOPadIOVdd
x4 IO_iovdd IO_iovss IO_vss IO_vdd sg13g2_IOPadIOVss
XX8 pvout bondpad size=80u shape=0 padtype=0
XX9 IO_iovdd bondpad size=80u shape=0 padtype=0
V2 IO_iovdd GND 3.3
V4 IO_iovss GND 0
x5 IO_iovdd IO_iovss IO_vss IO_vdd sg13g2_IOPadVdd
XX6 IO_vdd bondpad size=80u shape=0 padtype=0
V1 IO_vdd GND 1.2
V3 IO_vss GND 0
x10 IO_iovdd IO_iovss IO_vss IO_vdd sg13g2_IOPadVSS
XX11 IO_iovss bondpad size=80u shape=0 padtype=0
XX14 IO_vss bondpad size=80u shape=0 padtype=0
x15 IO_iovdd IO_iovss vout IO_vss IO_vdd pvout sg13g2_IOPadOut16mA
x13 IO_iovdd IO_iovss pv4 IO_vss IO_vdd iv4 sg13g2_IOPadIn
x16 IO_iovdd IO_iovss pv3 IO_vss IO_vdd iv3 sg13g2_IOPadIn
x17 IO_iovdd IO_iovss pv2 IO_vss IO_vdd iv2 sg13g2_IOPadIn
x18 IO_iovdd IO_iovss pv1 IO_vss IO_vdd iv1 sg13g2_IOPadIn
x19 IO_iovdd IO_iovss pv0 IO_vss IO_vdd iv0 sg13g2_IOPadIn
x20 IO_iovdd IO_iovss net1 IO_vss IO_vdd vcont sg13g2_IOPadAnalog
XX7 iv4 bondpad size=80u shape=0 padtype=0
XX12 iv3 bondpad size=80u shape=0 padtype=0
XX21 iv2 bondpad size=80u shape=0 padtype=0
XX22 iv1 bondpad size=80u shape=0 padtype=0
XX23 iv0 bondpad size=80u shape=0 padtype=0
XX24 vcont bondpad size=80u shape=0 padtype=0
x25 IO_vdd IO_vss IO_vss IO_vss IO_vss IO_vss vinI vinIB vout8i net2 IO_vss 8xPI_top
x26 IO_iovdd IO_iovss IO_vss IO_vdd sg13g2_IOPadIOVdd
x27 IO_iovdd IO_iovss IO_vss IO_vdd sg13g2_IOPadIOVss
XX28 pvout8i bondpad size=80u shape=0 padtype=0
XX29 IO_iovdd bondpad size=80u shape=0 padtype=0
x30 IO_iovdd IO_iovss IO_vss IO_vdd sg13g2_IOPadVdd
XX31 IO_vdd bondpad size=80u shape=0 padtype=0
x32 IO_iovdd IO_iovss IO_vss IO_vdd sg13g2_IOPadVSS
XX33 IO_iovss bondpad size=80u shape=0 padtype=0
XX34 IO_vss bondpad size=80u shape=0 padtype=0
x35 IO_iovdd IO_iovss vout8i IO_vss IO_vdd pvout8i sg13g2_IOPadOut16mA
x2 IO_iovdd IO_iovss net2 IO_vss IO_vdd vcont sg13g2_IOPadAnalog
XX36 vcont bondpad size=80u shape=0 padtype=0
x37 IO_vdd net4 iv2 GND inv
x38 IO_vdd v2 net4 GND inv
x39 IO_vdd net6 iv3 GND inv
x40 IO_vdd v3 net6 GND inv
x41 IO_vdd net7 iv1 GND inv
x42 IO_vdd v1 net7 GND inv
x43 IO_vdd net3 iv0 GND inv
x44 IO_vdd v0 net3 GND inv
x45 IO_vdd net5 iv4 GND inv
x46 IO_vdd v4 net5 GND inv
**** begin user architecture code

* Circuit Parameters
.param vdd = 1.2
.param vss = 0.0
.param SR_control=110p
.options TEMP = 27.0
.OPTION RSHUNT=1e10
.OPTION CSHUNT=1e-15
.option rseries = 1e-4
.option ITL1 = 500
.option ITL2 = 300
.option ITL4 = 150
.option maxord=2
.options method=gear reltol=5e-3 abstol=1e-8 vntol=1e-4
.options gmin=1e-9
.options pivtol=1e-10
.options chgtol=1e-12

* Include Models
*.lib /opt/pdks/ihp-sg13g2/libs.tech/ngspice/models/cornerMOSlv.lib mos_tt
*.lib /opt/pdks/ihp-sg13g2/libs.tech/ngspice/models/cornerMOShv.lib mos_tt
*.lib /opt/pdks/ihp-sg13g2/libs.tech/ngspice/models/cornerHBT.lib hbt_typ
*.lib /opt/pdks/ihp-sg13g2/libs.tech/ngspice/models/cornerRES.lib res_typ
*.lib cornerMOSlv.lib mos_tt

* OP Parameters & Singals to save
.save V(vout) V(pvout) V(vout8i) V(pvout8i) V(vinI) V(vinIB) V(x1.vsq[2]) V(x1.vsq[1]) V(x1.vsq[0]) V(x1.vst[7]) V(x1.vst[6]) V(x1.vst[5]) V(x1.vst[4]) V(x1.vst[3]) V(x1.vst[2]) V(x1.vst[1]) V(x1.vstq[7]) V(x1.vstq[6]) V(x1.vstq[5]) V(x1.vstq[4]) V(x1.vstq[3]) V(x1.vstq[2]) V(x1.vstq[1]) V(x1.vi) V(x1.vib) V(x1.vq) V(x1.vqb)

*Simulations
.control
*set output_path = tb_linearity_8xpi/
	tran 100PS 80NS
	*setplot tran1
	*plot v0 v1+1.5 v0_st+3 v6_st+4.5 Vout+6 Vout8I+7.5 ylabel vout xlabel vin
	display
	set filetype = ascii
        write tran_linearity_integration.raw
	*V(vout) V(vout8i) V(vinI) V(vinIB) V(@x1.vsq[2]) V(x1.vst[7]) V(x1.vstq[7]) V(x1.x1.vini) V(x1.x1.vinib) V(x1.x1.vinq) V(x1.x1.vinqb)
	*write {$output_path}tran_linearity_termoless.raw V(Vout) V(Vout8I) V(vinI) V(VoutI1) V(VoutI2) V(VoutQ1) V(VoutIB1) V(VoutQB1)
.endc
.end

.lib cornerMOSlv.lib mos_tt
.lib cornerMOShv.lib mos_tt
.lib cornerRES.lib res_typ
.include diodes.lib
.include sg13g2_bondpad.lib

**** end user architecture code
**.ends

* expanding   symbol:  /foss/designs/PhaseInterpolator/8xPI_top/8xPI_top.sym # of pins=7
** sym_path: /foss/designs/PhaseInterpolator/8xPI_top/8xPI_top.sym
** sch_path: /foss/designs/PhaseInterpolator/8xPI_top/8xPI_top.sch
.subckt 8xPI_top VDD VS[4] VS[3] VS[2] VS[1] VS[0] VINI VINIB VOUT VCONT VSS
*.ipin VINI
*.ipin VINIB
*.ipin VCONT
*.iopin VDD
*.iopin VSS
*.opin VOUT
*.ipin VS[4],VS[3],VS[2],VS[1],VS[0]
x1 VI VIB VQ VQB VSQ[1] VSQ[0] VSTQ[7] VSTQ[6] VSTQ[5] VSTQ[4] VSTQ[3] VSTQ[2] VSTQ[1] VSQ[2] VOUT VDD VSS 8xPI
x2 VDD VINI VCONT VINIB VSS VQ VIB VQB VI 2to4
x3 VST[7] VST[6] VST[5] VST[4] VST[3] VST[2] VST[1] VS[2] VS[1] VS[0] VDD VSS 3to7_deco_v2
x4 VDD VSQ[2] VSQ[1] VSQ[0] VS[4] VS[3] VSS VSTQ[7] VSTQ[6] VSTQ[5] VSTQ[4] VSTQ[3] VSTQ[2] VSTQ[1] VST[7] VST[6] VST[5] VST[4]
+ VST[3] VST[2] VST[1] 8xPI_logic
.ends

* expanding   symbol:  sg13g2_IOPadIOVdd.sym # of pins=4
** sym_path: /foss/designs/IHP-Open-PDK/ihp-sg13g2/libs.ref/sg13g2_io/xschem/sg13g2_IOPadIOVdd.sym
** sch_path: /foss/designs/IHP-Open-PDK/ihp-sg13g2/libs.ref/sg13g2_io/xschem/sg13g2_IOPadIOVdd.sch
.subckt sg13g2_IOPadIOVdd iovdd iovss vss vdd
*.iopin iovss
*.iopin iovdd
*.iopin vss
*.iopin vdd
x1 net2 iovdd sg13g2_RCClampResistor
x2 iovdd net1 net2 iovss sg13g2_RCClampInverter
.ends

* expanding   symbol:  sg13g2_IOPadIOVss.sym # of pins=4
** sym_path: /foss/designs/IHP-Open-PDK/ihp-sg13g2/libs.ref/sg13g2_io/xschem/sg13g2_IOPadIOVss.sym
** sch_path: /foss/designs/IHP-Open-PDK/ihp-sg13g2/libs.ref/sg13g2_io/xschem/sg13g2_IOPadIOVss.sch
.subckt sg13g2_IOPadIOVss iovdd iovss vss vdd
*.iopin iovss
*.iopin iovdd
*.iopin vdd
*.iopin vss
x8 iovss iovss iovdd sg13g2_DCNDiode
x9 iovdd iovss iovss sg13g2_DCPDiode
* noconn vdd
* noconn vss
.ends

* expanding   symbol:  sg13g2_IOPadVdd.sym # of pins=4
** sym_path: /foss/designs/IHP-Open-PDK/ihp-sg13g2/libs.ref/sg13g2_io/xschem/sg13g2_IOPadVdd.sym
** sch_path: /foss/designs/IHP-Open-PDK/ihp-sg13g2/libs.ref/sg13g2_io/xschem/sg13g2_IOPadVdd.sch
.subckt sg13g2_IOPadVdd iovdd iovss vss vdd
*.iopin vdd
*.iopin iovdd
*.iopin vss
*.iopin iovss
x6 vdd net2 sg13g2_RCClampResistor
x1 vdd net1 net2 vss sg13g2_RCClampInverter
.ends

* expanding   symbol:  sg13g2_IOPadVSS.sym # of pins=4
** sym_path: /foss/designs/IHP-Open-PDK/ihp-sg13g2/libs.ref/sg13g2_io/xschem/sg13g2_IOPadVSS.sym
** sch_path: /foss/designs/IHP-Open-PDK/ihp-sg13g2/libs.ref/sg13g2_io/xschem/sg13g2_IOPadVSS.sch
.subckt sg13g2_IOPadVSS iovdd iovss vss vdd
*.iopin iovss
*.iopin iovdd
*.iopin vss
*.iopin vdd
x1 vss iovss iovdd sg13g2_DCNDiode
x2 iovdd vss iovss sg13g2_DCPDiode
* noconn vdd
.ends

* expanding   symbol:  sg13g2_IOPadOut16mA.sym # of pins=6
** sym_path: /foss/designs/IHP-Open-PDK/ihp-sg13g2/libs.ref/sg13g2_io/xschem/sg13g2_IOPadOut16mA.sym
** sch_path: /foss/designs/IHP-Open-PDK/ihp-sg13g2/libs.ref/sg13g2_io/xschem/sg13g2_IOPadOut16mA.sch
.subckt sg13g2_IOPadOut16mA iovdd iovss c2p vss vdd pad
*.iopin iovss
*.iopin pad
*.iopin vss
*.iopin c2p
*.iopin vdd
*.iopin iovdd
x1 iovdd pad net2 iovss sg13g2_Clamp_N8N8D
x3 pad iovss iovdd sg13g2_DCNDiode
x4 iovdd pad iovss sg13g2_DCPDiode
x5 vdd iovdd net2 net1 c2p vss sg13g2_GateLevelUpInv
x2 iovdd net1 pad iovss sg13g2_Clamp_P8N8D
.ends

* expanding   symbol:  sg13g2_IOPadIn.sym # of pins=6
** sym_path: /foss/designs/IHP-Open-PDK/ihp-sg13g2/libs.ref/sg13g2_io/xschem/sg13g2_IOPadIn.sym
** sch_path: /foss/designs/IHP-Open-PDK/ihp-sg13g2/libs.ref/sg13g2_io/xschem/sg13g2_IOPadIn.sch
.subckt sg13g2_IOPadIn iovdd iovss p2c vss vdd pad
*.iopin iovdd
*.iopin vdd
*.iopin vss
*.iopin iovss
*.iopin p2c
*.iopin pad
x1 pad iovss iovdd sg13g2_DCNDiode
x2 iovdd pad iovss sg13g2_DCPDiode
x3 vdd iovdd p2c pad iovss vss sg13g2_LevelDown
.ends

* expanding   symbol:  sg13g2_IOPadAnalog.sym # of pins=6
** sym_path: /foss/designs/IHP-Open-PDK/ihp-sg13g2/libs.ref/sg13g2_io/xschem/sg13g2_IOPadAnalog.sym
** sch_path: /foss/designs/IHP-Open-PDK/ihp-sg13g2/libs.ref/sg13g2_io/xschem/sg13g2_IOPadAnalog.sch
.subckt sg13g2_IOPadAnalog iovdd iovss padres vss vdd pad
*.iopin padres
*.iopin iovss
*.iopin iovdd
*.iopin pad
*.iopin vdd
*.iopin vss
x3 pad iovss iovdd sg13g2_DCNDiode
x4 iovdd pad iovss sg13g2_DCPDiode
x1 pad iovdd iovss sg13g2_Clamp_N20N0D
x2 iovdd pad iovss sg13g2_Clamp_P20N0D
x5 iovdd pad padres iovss sg13g2_SecondaryProtection
.ends

* expanding   symbol:  /foss/designs/PhaseInterpolator/Custom_std_cells/inv.sym # of pins=4
** sym_path: /foss/designs/PhaseInterpolator/Custom_std_cells/inv.sym
** sch_path: /foss/designs/PhaseInterpolator/Custom_std_cells/inv.sch
.subckt inv VDD VOUT VIN VSS
*.iopin VDD
*.iopin VSS
*.opin VOUT
*.ipin VIN
XM2 VOUT VIN VDD VDD sg13_lv_pmos w=0.15u l=0.13u ng=1 m=1
XM1 VOUT VIN VSS VSS sg13_lv_nmos w=0.15u l=0.13u ng=1 m=1
.ends

* expanding   symbol:  /foss/designs/PhaseInterpolator/8xPI/8xPI.sym # of pins=9
** sym_path: /foss/designs/PhaseInterpolator/8xPI/8xPI.sym
** sch_path: /foss/designs/PhaseInterpolator/8xPI/8xPI.sch
.subckt 8xPI VINI VINIB VINQ VINQB VS[1] VS[0] VST[7] VST[6] VST[5] VST[4] VST[3] VST[2] VST[1] VST[0] VOUT VDD VSS
*.ipin VINI
*.ipin VINQ
*.ipin VINIB
*.ipin VINQB
*.iopin VDD
*.iopin VSS
*.opin VOUT
*.ipin VS[1],VS[0]
*.ipin VST[7],VST[6],VST[5],VST[4],VST[3],VST[2],VST[1],VST[0]
x1[7] VINI VINIB VDD net1 VS[1] VS[0] VINQ VSS VINQB VST[7] MUX_4_1
x1[6] VINI VINIB VDD net1 VS[1] VS[0] VINQ VSS VINQB VST[6] MUX_4_1
x1[5] VINI VINIB VDD net1 VS[1] VS[0] VINQ VSS VINQB VST[5] MUX_4_1
x1[4] VINI VINIB VDD net1 VS[1] VS[0] VINQ VSS VINQB VST[4] MUX_4_1
x1[3] VINI VINIB VDD net1 VS[1] VS[0] VINQ VSS VINQB VST[3] MUX_4_1
x1[2] VINI VINIB VDD net1 VS[1] VS[0] VINQ VSS VINQB VST[2] MUX_4_1
x1[1] VINI VINIB VDD net1 VS[1] VS[0] VINQ VSS VINQB VST[1] MUX_4_1
x1[0] VINI VINIB VDD net1 VS[1] VS[0] VINQ VSS VINQB VST[0] MUX_4_1
x2 VDD net2 net1 VSS inv_PI
x1 VDD VOUT net2 VSS buff_PI_d16
.ends

* expanding   symbol:  /foss/designs/PhaseInterpolator/2to4/2to4.sym # of pins=9
** sym_path: /foss/designs/PhaseInterpolator/2to4/2to4.sym
** sch_path: /foss/designs/PhaseInterpolator/2to4/2to4.sch
.subckt 2to4 VDD VINI VCONT VINIB VSS VQ VIB VQB VI
*.ipin VCONT
*.ipin VINI
*.opin VIB
*.opin VQ
*.ipin VINIB
*.opin VI
*.opin VQB
*.iopin VDD
*.iopin VSS
x1 VDD VQB VQ VCONT net5 net3 VSS dcvsl_variable
x2 VDD VIB net1 VSS buff_PI_d16
x3 VDD VI net2 VSS buff_PI_d16
x4 VDD net1 VINI VSS inv_PI
x5 VDD net2 VINIB VSS inv_PI
x6 VDD net3 net4 VSS buff_PI_d16
x7 VDD net4 VINIB VSS inv_PI
x8 VDD net5 net6 VSS buff_PI_d16
x9 VDD net6 VINI VSS inv_PI
.ends

* expanding   symbol:  /foss/designs/PhaseInterpolator/BinarytoThermo/3to7_deco_v2.sym # of pins=4
** sym_path: /foss/designs/PhaseInterpolator/BinarytoThermo/3to7_deco_v2.sym
** sch_path: /foss/designs/PhaseInterpolator/BinarytoThermo/3to7_deco_v2.sch
.subckt 3to7_deco_v2 ST[7] ST[6] ST[5] ST[4] ST[3] ST[2] ST[1] S[2] S[1] S[0] VDD VSS
*.opin ST[7],ST[6],ST[5],ST[4],ST[3],ST[2],ST[1]
*.ipin S[2],S[1],S[0]
*.iopin VDD
*.iopin VSS
x1 VDD net3 S[2] VSS inv
x2 VDD net2 S[1] VSS inv
x3 VDD net1 S[0] VSS inv
x4 VDD net1 net2 net3 ST[1] VSS nor_x3_custom
x5 VDD net2 ST[2] net3 VSS nor_custom
x6 VDD net5 ST[3] net3 VSS nor_custom
x7 VDD ST[4] net3 VSS inv
x8 VDD ST[5] net4 net3 VSS nand_custom
x9 VDD ST[6] net2 net3 VSS nand_custom
x11 VDD net5 net2 net1 VSS and_custom
x12 VDD net1 net4 net2 VSS or_custom
x10 VDD ST[7] net1 net2 net3 VSS nand_x3_custom
.ends

* expanding   symbol:  /foss/designs/PhaseInterpolator/8xPI_logic/8xPI_logic.sym # of pins=6
** sym_path: /foss/designs/PhaseInterpolator/8xPI_logic/8xPI_logic.sym
** sch_path: /foss/designs/PhaseInterpolator/8xPI_logic/8xPI_logic.sch
.subckt 8xPI_logic VDD SQ[2] SQ[1] SQ[0] S[4] S[3] VSS STQ[7] STQ[6] STQ[5] STQ[4] STQ[3] STQ[2] STQ[1] ST[7] ST[6] ST[5] ST[4]
+ ST[3] ST[2] ST[1]
*.ipin S[4],S[3]
*.iopin VSS
*.opin STQ[7],STQ[6],STQ[5],STQ[4],STQ[3],STQ[2],STQ[1]
*.ipin ST[7],ST[6],ST[5],ST[4],ST[3],ST[2],ST[1]
*.iopin VDD
*.opin SQ[2],SQ[1],SQ[0]
x1 VDD net1 S[4] VSS inv
x2 VDD SQ[1] net1 VSS inv
x3 VDD S[3] VSS SQ[0] S[4] xor_custom
x4 VDD net2 S[3] VSS inv
x5 VDD SQ[2] net2 VSS inv
x6[6] VDD SCb[7] Sbuff[3] VSS inv
x6[5] VDD SCb[6] Sbuff[3] VSS inv
x6[4] VDD SCb[5] Sbuff[3] VSS inv
x6[3] VDD SCb[4] Sbuff[3] VSS inv
x6[2] VDD SCb[3] Sbuff[3] VSS inv
x6[1] VDD SCb[2] Sbuff[3] VSS inv
x6[0] VDD SCb[1] Sbuff[3] VSS inv
x7[6] VDD SC[7] SCb[7] VSS inv
x7[5] VDD SC[6] SCb[6] VSS inv
x7[4] VDD SC[5] SCb[5] VSS inv
x7[3] VDD SC[4] SCb[4] VSS inv
x7[2] VDD SC[3] SCb[3] VSS inv
x7[1] VDD SC[2] SCb[2] VSS inv
x7[0] VDD SC[1] SCb[1] VSS inv
x1[6] VDD ST[7] VSS STQ[7] SC[7] xor_custom
x1[5] VDD ST[6] VSS STQ[6] SC[6] xor_custom
x1[4] VDD ST[5] VSS STQ[5] SC[5] xor_custom
x1[3] VDD ST[4] VSS STQ[4] SC[4] xor_custom
x1[2] VDD ST[3] VSS STQ[3] SC[3] xor_custom
x1[1] VDD ST[2] VSS STQ[2] SC[2] xor_custom
x1[0] VDD ST[1] VSS STQ[1] SC[1] xor_custom
x6 VDD Sbuff[3] S[3] VSS buff_d8
.ends

* expanding   symbol:  sg13g2_RCClampResistor.sym # of pins=2
** sym_path: /foss/designs/IHP-Open-PDK/ihp-sg13g2/libs.ref/sg13g2_io/xschem/sg13g2_RCClampResistor.sym
** sch_path: /foss/designs/IHP-Open-PDK/ihp-sg13g2/libs.ref/sg13g2_io/xschem/sg13g2_RCClampResistor.sch
.subckt sg13g2_RCClampResistor pin2 pin1
*.iopin pin1
*.iopin pin2
XR1 pin1 net1 sub! rppd w=1.0e-6 l=20.0e-6 m=1 b=0
XR2 net1 net2 sub! rppd w=1.0e-6 l=20.0e-6 m=1 b=0
XR3 net2 net3 sub! rppd w=1.0e-6 l=20.0e-6 m=1 b=0
XR4 net3 net4 sub! rppd w=1.0e-6 l=20.0e-6 m=1 b=0
XR5 net8 net7 sub! rppd w=1.0e-6 l=20.0e-6 m=1 b=0
XR6 net7 net6 sub! rppd w=1.0e-6 l=20.0e-6 m=1 b=0
XR7 net6 net5 sub! rppd w=1.0e-6 l=20.0e-6 m=1 b=0
XR8 net5 net4 sub! rppd w=1.0e-6 l=20.0e-6 m=1 b=0
XR9 net8 net9 sub! rppd w=1.0e-6 l=20.0e-6 m=1 b=0
XR10 net9 net10 sub! rppd w=1.0e-6 l=20.0e-6 m=1 b=0
XR11 net10 net11 sub! rppd w=1.0e-6 l=20.0e-6 m=1 b=0
XR12 net11 net12 sub! rppd w=1.0e-6 l=20.0e-6 m=1 b=0
XR13 net16 net15 sub! rppd w=1.0e-6 l=20.0e-6 m=1 b=0
XR14 net15 net14 sub! rppd w=1.0e-6 l=20.0e-6 m=1 b=0
XR15 net14 net13 sub! rppd w=1.0e-6 l=20.0e-6 m=1 b=0
XR16 net13 net12 sub! rppd w=1.0e-6 l=20.0e-6 m=1 b=0
XR17 net16 net17 sub! rppd w=1.0e-6 l=20.0e-6 m=1 b=0
XR18 net17 net18 sub! rppd w=1.0e-6 l=20.0e-6 m=1 b=0
XR19 net18 net19 sub! rppd w=1.0e-6 l=20.0e-6 m=1 b=0
XR20 net19 net20 sub! rppd w=1.0e-6 l=20.0e-6 m=1 b=0
XR21 net24 net23 sub! rppd w=1.0e-6 l=20.0e-6 m=1 b=0
XR22 net23 net22 sub! rppd w=1.0e-6 l=20.0e-6 m=1 b=0
XR23 net22 net21 sub! rppd w=1.0e-6 l=20.0e-6 m=1 b=0
XR24 net21 net20 sub! rppd w=1.0e-6 l=20.0e-6 m=1 b=0
XR25 net24 net25 sub! rppd w=1.0e-6 l=20.0e-6 m=1 b=0
XR26 net25 pin2 sub! rppd w=1.0e-6 l=20.0e-6 m=1 b=0
.ends

* expanding   symbol:  sg13g2_RCClampInverter.sym # of pins=4
** sym_path: /foss/designs/IHP-Open-PDK/ihp-sg13g2/libs.ref/sg13g2_io/xschem/sg13g2_RCClampInverter.sym
** sch_path: /foss/designs/IHP-Open-PDK/ihp-sg13g2/libs.ref/sg13g2_io/xschem/sg13g2_RCClampInverter.sch
.subckt sg13g2_RCClampInverter supply out in ground
*.iopin supply
*.iopin ground
*.opin out
*.ipin in
XM1 ground in ground ground sg13_hv_nmos w=9.0u l=9.5u ng=1 m=1
XM2 ground in ground ground sg13_hv_nmos w=9.0u l=9.5u ng=1 m=1
XM3 ground in ground ground sg13_hv_nmos w=9.0u l=9.5u ng=1 m=1
XM4 ground in ground ground sg13_hv_nmos w=9.0u l=9.5u ng=1 m=1
XM5 ground in ground ground sg13_hv_nmos w=9.0u l=9.5u ng=1 m=1
XM6 ground in ground ground sg13_hv_nmos w=9.0u l=9.5u ng=1 m=1
XM7 ground in ground ground sg13_hv_nmos w=9.0u l=9.5u ng=1 m=1
XM8 ground in ground ground sg13_hv_nmos w=9.0u l=9.5u ng=1 m=1
XM9 ground in ground ground sg13_hv_nmos w=9.0u l=9.5u ng=1 m=1
XM10 ground in ground ground sg13_hv_nmos w=9.0u l=9.5u ng=1 m=1
XM11 ground in ground ground sg13_hv_nmos w=9.0u l=9.5u ng=1 m=1
XM12 ground in ground ground sg13_hv_nmos w=9.0u l=9.5u ng=1 m=1
XM13 ground in ground ground sg13_hv_nmos w=9.0u l=9.5u ng=1 m=1
XM14 ground in ground ground sg13_hv_nmos w=9.0u l=9.5u ng=1 m=1
XM15 out in ground ground sg13_hv_nmos w=9.0u l=0.5u ng=1 m=1
XM16 out in ground ground sg13_hv_nmos w=9.0u l=0.5u ng=1 m=1
XM17 out in ground ground sg13_hv_nmos w=9.0u l=0.5u ng=1 m=1
XM18 out in ground ground sg13_hv_nmos w=9.0u l=0.5u ng=1 m=1
XM19 out in ground ground sg13_hv_nmos w=9.0u l=0.5u ng=1 m=1
XM20 out in ground ground sg13_hv_nmos w=9.0u l=0.5u ng=1 m=1
XM21 out in ground ground sg13_hv_nmos w=9.0u l=0.5u ng=1 m=1
XM22 out in ground ground sg13_hv_nmos w=9.0u l=0.5u ng=1 m=1
XM23 out in ground ground sg13_hv_nmos w=9.0u l=0.5u ng=1 m=1
XM24 out in ground ground sg13_hv_nmos w=9.0u l=0.5u ng=1 m=1
XM25 out in ground ground sg13_hv_nmos w=9.0u l=0.5u ng=1 m=1
XM26 out in ground ground sg13_hv_nmos w=9.0u l=0.5u ng=1 m=1
XM27 out in supply supply sg13_hv_pmos w=7.0u l=0.5u ng=1 m=1
XM28 out in supply supply sg13_hv_pmos w=7.0u l=0.5u ng=1 m=1
XM29 out in supply supply sg13_hv_pmos w=7.0u l=0.5u ng=1 m=1
XM30 out in supply supply sg13_hv_pmos w=7.0u l=0.5u ng=1 m=1
XM31 out in supply supply sg13_hv_pmos w=7.0u l=0.5u ng=1 m=1
XM32 out in supply supply sg13_hv_pmos w=7.0u l=0.5u ng=1 m=1
XM33 out in supply supply sg13_hv_pmos w=7.0u l=0.5u ng=1 m=1
XM34 out in supply supply sg13_hv_pmos w=7.0u l=0.5u ng=1 m=1
XM35 out in supply supply sg13_hv_pmos w=7.0u l=0.5u ng=1 m=1
XM36 out in supply supply sg13_hv_pmos w=7.0u l=0.5u ng=1 m=1
XM37 out in supply supply sg13_hv_pmos w=7.0u l=0.5u ng=1 m=1
XM38 out in supply supply sg13_hv_pmos w=7.0u l=0.5u ng=1 m=1
XM39 out in supply supply sg13_hv_pmos w=7.0u l=0.5u ng=1 m=1
XM40 out in supply supply sg13_hv_pmos w=7.0u l=0.5u ng=1 m=1
XM41 out in supply supply sg13_hv_pmos w=7.0u l=0.5u ng=1 m=1
XM42 out in supply supply sg13_hv_pmos w=7.0u l=0.5u ng=1 m=1
XM43 out in supply supply sg13_hv_pmos w=7.0u l=0.5u ng=1 m=1
XM44 out in supply supply sg13_hv_pmos w=7.0u l=0.5u ng=1 m=1
XM45 out in supply supply sg13_hv_pmos w=7.0u l=0.5u ng=1 m=1
XM46 out in supply supply sg13_hv_pmos w=7.0u l=0.5u ng=1 m=1
XM47 out in supply supply sg13_hv_pmos w=7.0u l=0.5u ng=1 m=1
XM48 out in supply supply sg13_hv_pmos w=7.0u l=0.5u ng=1 m=1
XM49 out in supply supply sg13_hv_pmos w=7.0u l=0.5u ng=1 m=1
XM50 out in supply supply sg13_hv_pmos w=7.0u l=0.5u ng=1 m=1
XM51 out in supply supply sg13_hv_pmos w=7.0u l=0.5u ng=1 m=1
XM52 out in supply supply sg13_hv_pmos w=7.0u l=0.5u ng=1 m=1
XM53 out in supply supply sg13_hv_pmos w=7.0u l=0.5u ng=1 m=1
XM54 out in supply supply sg13_hv_pmos w=7.0u l=0.5u ng=1 m=1
XM55 out in supply supply sg13_hv_pmos w=7.0u l=0.5u ng=1 m=1
XM56 out in supply supply sg13_hv_pmos w=7.0u l=0.5u ng=1 m=1
XM57 out in supply supply sg13_hv_pmos w=7.0u l=0.5u ng=1 m=1
XM58 out in supply supply sg13_hv_pmos w=7.0u l=0.5u ng=1 m=1
XM59 out in supply supply sg13_hv_pmos w=7.0u l=0.5u ng=1 m=1
XM60 out in supply supply sg13_hv_pmos w=7.0u l=0.5u ng=1 m=1
XM61 out in supply supply sg13_hv_pmos w=7.0u l=0.5u ng=1 m=1
XM62 out in supply supply sg13_hv_pmos w=7.0u l=0.5u ng=1 m=1
XM63 out in supply supply sg13_hv_pmos w=7.0u l=0.5u ng=1 m=1
XM64 out in supply supply sg13_hv_pmos w=7.0u l=0.5u ng=1 m=1
XM65 out in supply supply sg13_hv_pmos w=7.0u l=0.5u ng=1 m=1
XM66 out in supply supply sg13_hv_pmos w=7.0u l=0.5u ng=1 m=1
XM67 out in supply supply sg13_hv_pmos w=7.0u l=0.5u ng=1 m=1
XM68 out in supply supply sg13_hv_pmos w=7.0u l=0.5u ng=1 m=1
XM69 out in supply supply sg13_hv_pmos w=7.0u l=0.5u ng=1 m=1
XM70 out in supply supply sg13_hv_pmos w=7.0u l=0.5u ng=1 m=1
XM71 out in supply supply sg13_hv_pmos w=7.0u l=0.5u ng=1 m=1
XM72 out in supply supply sg13_hv_pmos w=7.0u l=0.5u ng=1 m=1
XM73 out in supply supply sg13_hv_pmos w=7.0u l=0.5u ng=1 m=1
XM74 net1 in supply supply sg13_hv_pmos w=7.0u l=0.5u ng=1 m=1
XM75 out in supply supply sg13_hv_pmos w=7.0u l=0.5u ng=1 m=1
XM76 out in supply supply sg13_hv_pmos w=7.0u l=0.5u ng=1 m=1
.ends

* expanding   symbol:  sg13g2_DCNDiode.sym # of pins=3
** sym_path: /foss/designs/IHP-Open-PDK/ihp-sg13g2/libs.ref/sg13g2_io/xschem/sg13g2_DCNDiode.sym
** sch_path: /foss/designs/IHP-Open-PDK/ihp-sg13g2/libs.ref/sg13g2_io/xschem/sg13g2_DCNDiode.sch
.subckt sg13g2_DCNDiode cathode anode guard
*.iopin cathode
*.iopin anode
*.iopin guard
XD1 anode cathode dantenna l=1.26u w=27.78u
XD2 anode cathode dantenna l=1.26u w=27.78u
* noconn guard
.ends

* expanding   symbol:  sg13g2_DCPDiode.sym # of pins=3
** sym_path: /foss/designs/IHP-Open-PDK/ihp-sg13g2/libs.ref/sg13g2_io/xschem/sg13g2_DCPDiode.sym
** sch_path: /foss/designs/IHP-Open-PDK/ihp-sg13g2/libs.ref/sg13g2_io/xschem/sg13g2_DCPDiode.sch
.subckt sg13g2_DCPDiode cathode anode guard
*.iopin cathode
*.iopin anode
*.iopin guard
XD1 anode cathode dpantenna l=1.26u w=27.78u
XD2 anode cathode dpantenna l=1.26u w=27.78u
* noconn guard
.ends

* expanding   symbol:  sg13g2_Clamp_N8N8D.sym # of pins=4
** sym_path: /foss/designs/IHP-Open-PDK/ihp-sg13g2/libs.ref/sg13g2_io/xschem/sg13g2_Clamp_N8N8D.sym
** sch_path: /foss/designs/IHP-Open-PDK/ihp-sg13g2/libs.ref/sg13g2_io/xschem/sg13g2_Clamp_N8N8D.sch
.subckt sg13g2_Clamp_N8N8D iovdd pad gate iovss
*.iopin iovss
*.iopin pad
*.iopin gate
*.iopin iovdd
XM1 pad gate iovss iovss sg13_hv_nmos w=4.4u l=0.6u ng=1 m=1
XM2 pad gate iovss iovss sg13_hv_nmos w=4.4u l=0.6u ng=1 m=1
XM3 pad gate iovss iovss sg13_hv_nmos w=4.4u l=0.6u ng=1 m=1
XM4 pad gate iovss iovss sg13_hv_nmos w=4.4u l=0.6u ng=1 m=1
XM5 pad gate iovss iovss sg13_hv_nmos w=4.4u l=0.6u ng=1 m=1
XM6 pad gate iovss iovss sg13_hv_nmos w=4.4u l=0.6u ng=1 m=1
XM7 pad gate iovss iovss sg13_hv_nmos w=4.4u l=0.6u ng=1 m=1
XM8 pad gate iovss iovss sg13_hv_nmos w=4.4u l=0.6u ng=1 m=1
XD1 iovss gate dantenna l=0.64u w=0.3u
.ends

* expanding   symbol:  sg13g2_GateLevelUpInv.sym # of pins=6
** sym_path: /foss/designs/IHP-Open-PDK/ihp-sg13g2/libs.ref/sg13g2_io/xschem/sg13g2_GateLevelUpInv.sym
** sch_path: /foss/designs/IHP-Open-PDK/ihp-sg13g2/libs.ref/sg13g2_io/xschem/sg13g2_GateLevelUpInv.sch
.subckt sg13g2_GateLevelUpInv vdd iovdd ngate pgate core vss
*.iopin vdd
*.iopin iovdd
*.iopin core
*.iopin vss
*.iopin pgate
*.iopin ngate
x1 iovdd vdd ngate core vss sg13g2_LevelUpInv
x2 iovdd vdd pgate core vss sg13g2_LevelUpInv
.ends

* expanding   symbol:  sg13g2_Clamp_P8N8D.sym # of pins=4
** sym_path: /foss/designs/IHP-Open-PDK/ihp-sg13g2/libs.ref/sg13g2_io/xschem/sg13g2_Clamp_P8N8D.sym
** sch_path: /foss/designs/IHP-Open-PDK/ihp-sg13g2/libs.ref/sg13g2_io/xschem/sg13g2_Clamp_P8N8D.sch
.subckt sg13g2_Clamp_P8N8D iovdd gate pad iovss
*.iopin iovdd
*.iopin gate
*.iopin pad
*.iopin iovss
XM1 pad gate iovdd iovdd sg13_hv_pmos w=6.66u l=0.6u ng=1 m=1
XM2 pad gate iovdd iovdd sg13_hv_pmos w=6.66u l=0.6u ng=1 m=1
XM3 pad gate iovdd iovdd sg13_hv_pmos w=6.66u l=0.6u ng=1 m=1
XM4 pad gate iovdd iovdd sg13_hv_pmos w=6.66u l=0.6u ng=1 m=1
XM5 pad gate iovdd iovdd sg13_hv_pmos w=6.66u l=0.6u ng=1 m=1
XM6 pad gate iovdd iovdd sg13_hv_pmos w=6.66u l=0.6u ng=1 m=1
XM7 pad gate iovdd iovdd sg13_hv_pmos w=6.66u l=0.6u ng=1 m=1
XM8 pad gate iovdd iovdd sg13_hv_pmos w=6.66u l=0.6u ng=1 m=1
XM9 pad gate iovdd iovdd sg13_hv_pmos w=6.66u l=0.6u ng=1 m=1
XM10 pad gate iovdd iovdd sg13_hv_pmos w=6.66u l=0.6u ng=1 m=1
XM11 pad gate iovdd iovdd sg13_hv_pmos w=6.66u l=0.6u ng=1 m=1
XM12 pad gate iovdd iovdd sg13_hv_pmos w=6.66u l=0.6u ng=1 m=1
XM13 pad gate iovdd iovdd sg13_hv_pmos w=6.66u l=0.6u ng=1 m=1
XM14 pad gate iovdd iovdd sg13_hv_pmos w=6.66u l=0.6u ng=1 m=1
XM15 pad gate iovdd iovdd sg13_hv_pmos w=6.66u l=0.6u ng=1 m=1
XM16 pad gate iovdd iovdd sg13_hv_pmos w=6.66u l=0.6u ng=1 m=1
XD1 gate iovdd dpantenna l=0.64u w=0.3u
.ends

* expanding   symbol:  sg13g2_LevelDown.sym # of pins=6
** sym_path: /foss/designs/IHP-Open-PDK/ihp-sg13g2/libs.ref/sg13g2_io/xschem/sg13g2_LevelDown.sym
** sch_path: /foss/designs/IHP-Open-PDK/ihp-sg13g2/libs.ref/sg13g2_io/xschem/sg13g2_LevelDown.sch
.subckt sg13g2_LevelDown vdd iovdd core pad iovss vss
*.iopin vdd
*.iopin vss
*.iopin iovdd
*.iopin iovss
*.iopin pad
*.iopin core
XM1 vss net2 net1 vss sg13_hv_nmos w=2.65u l=0.45u ng=1 m=1
XM2 net1 net2 vdd vdd sg13_hv_pmos w=4.65u l=0.45u ng=1 m=1
XM3 vss net1 core vss sg13_lv_nmos w=2.75u l=0.13u ng=1 m=1
XM4 core net1 vdd vdd sg13_lv_pmos w=4.75u l=0.13u ng=1 m=1
x1 iovdd pad net2 iovss sg13g2_SecondaryProtection
.ends

* expanding   symbol:  sg13g2_Clamp_N20N0D.sym # of pins=3
** sym_path: /foss/designs/IHP-Open-PDK/ihp-sg13g2/libs.ref/sg13g2_io/xschem/sg13g2_Clamp_N20N0D.sym
** sch_path: /foss/designs/IHP-Open-PDK/ihp-sg13g2/libs.ref/sg13g2_io/xschem/sg13g2_Clamp_N20N0D.sch
.subckt sg13g2_Clamp_N20N0D pad iovdd iovss
*.iopin iovss
*.iopin pad
*.iopin iovdd
XM1 iovss net1 pad iovss sg13_hv_nmos w=4.4u l=0.6u ng=1 m=1
XM2 pad net1 iovss iovss sg13_hv_nmos w=4.4u l=0.6u ng=1 m=1
XM3 iovss net1 pad iovss sg13_hv_nmos w=4.4u l=0.6u ng=1 m=1
XM4 pad net1 iovss iovss sg13_hv_nmos w=4.4u l=0.6u ng=1 m=1
XM5 iovss net1 pad iovss sg13_hv_nmos w=4.4u l=0.6u ng=1 m=1
XM6 pad net1 iovss iovss sg13_hv_nmos w=4.4u l=0.6u ng=1 m=1
XM7 iovss net1 pad iovss sg13_hv_nmos w=4.4u l=0.6u ng=1 m=1
XM8 pad net1 iovss iovss sg13_hv_nmos w=4.4u l=0.6u ng=1 m=1
XM9 iovss net1 pad iovss sg13_hv_nmos w=4.4u l=0.6u ng=1 m=1
XM10 pad net1 iovss iovss sg13_hv_nmos w=4.4u l=0.6u ng=1 m=1
XM11 iovss net1 pad iovss sg13_hv_nmos w=4.4u l=0.6u ng=1 m=1
XM12 pad net1 iovss iovss sg13_hv_nmos w=4.4u l=0.6u ng=1 m=1
XM13 iovss net1 pad iovss sg13_hv_nmos w=4.4u l=0.6u ng=1 m=1
XM14 pad net1 iovss iovss sg13_hv_nmos w=4.4u l=0.6u ng=1 m=1
XM15 iovss net1 pad iovss sg13_hv_nmos w=4.4u l=0.6u ng=1 m=1
XM16 iovss net1 pad iovss sg13_hv_nmos w=4.4u l=0.6u ng=1 m=1
XM17 pad net1 iovss iovss sg13_hv_nmos w=4.4u l=0.6u ng=1 m=1
XM18 iovss net1 pad iovss sg13_hv_nmos w=4.4u l=0.6u ng=1 m=1
XM19 pad net1 iovss iovss sg13_hv_nmos w=4.4u l=0.6u ng=1 m=1
XM20 iovss net1 pad iovss sg13_hv_nmos w=4.4u l=0.6u ng=1 m=1
XR1 iovss net1 sub! rppd w=0.5e-6 l=0.5e-6 m=1 b=0
.ends

* expanding   symbol:  sg13g2_Clamp_P20N0D.sym # of pins=3
** sym_path: /foss/designs/IHP-Open-PDK/ihp-sg13g2/libs.ref/sg13g2_io/xschem/sg13g2_Clamp_P20N0D.sym
** sch_path: /foss/designs/IHP-Open-PDK/ihp-sg13g2/libs.ref/sg13g2_io/xschem/sg13g2_Clamp_P20N0D.sch
.subckt sg13g2_Clamp_P20N0D iovdd pad iovss
*.iopin iovdd
*.iopin pad
*.iopin iovss
XM1 pad net1 iovdd iovdd sg13_hv_pmos w=6.66u l=0.6u ng=1 m=1
XM2 iovdd net1 pad iovdd sg13_hv_pmos w=6.66u l=0.6u ng=1 m=1
XM3 pad net1 iovdd iovdd sg13_hv_pmos w=6.66u l=0.6u ng=1 m=1
XM4 iovdd net1 pad iovdd sg13_hv_pmos w=6.66u l=0.6u ng=1 m=1
XM5 pad net1 iovdd iovdd sg13_hv_pmos w=6.66u l=0.6u ng=1 m=1
XM6 iovdd net1 pad iovdd sg13_hv_pmos w=6.66u l=0.6u ng=1 m=1
XM7 pad net1 iovdd iovdd sg13_hv_pmos w=6.66u l=0.6u ng=1 m=1
XM8 iovdd net1 pad iovdd sg13_hv_pmos w=6.66u l=0.6u ng=1 m=1
XM9 pad net1 iovdd iovdd sg13_hv_pmos w=6.66u l=0.6u ng=1 m=1
XM10 iovdd net1 pad iovdd sg13_hv_pmos w=6.66u l=0.6u ng=1 m=1
XM11 pad net1 iovdd iovdd sg13_hv_pmos w=6.66u l=0.6u ng=1 m=1
XM12 iovdd net1 pad iovdd sg13_hv_pmos w=6.66u l=0.6u ng=1 m=1
XM13 pad net1 iovdd iovdd sg13_hv_pmos w=6.66u l=0.6u ng=1 m=1
XM14 iovdd net1 pad iovdd sg13_hv_pmos w=6.66u l=0.6u ng=1 m=1
XM15 pad net1 iovdd iovdd sg13_hv_pmos w=6.66u l=0.6u ng=1 m=1
XM16 iovdd net1 pad iovdd sg13_hv_pmos w=6.66u l=0.6u ng=1 m=1
XM17 pad net1 iovdd iovdd sg13_hv_pmos w=6.66u l=0.6u ng=1 m=1
XM18 iovdd net1 pad iovdd sg13_hv_pmos w=6.66u l=0.6u ng=1 m=1
XM19 pad net1 iovdd iovdd sg13_hv_pmos w=6.66u l=0.6u ng=1 m=1
XM20 iovdd net1 pad iovdd sg13_hv_pmos w=6.66u l=0.6u ng=1 m=1
XM21 pad net1 iovdd iovdd sg13_hv_pmos w=6.66u l=0.6u ng=1 m=1
XM22 iovdd net1 pad iovdd sg13_hv_pmos w=6.66u l=0.6u ng=1 m=1
XM23 pad net1 iovdd iovdd sg13_hv_pmos w=6.66u l=0.6u ng=1 m=1
XM24 iovdd net1 pad iovdd sg13_hv_pmos w=6.66u l=0.6u ng=1 m=1
XM25 pad net1 iovdd iovdd sg13_hv_pmos w=6.66u l=0.6u ng=1 m=1
XM26 iovdd net1 pad iovdd sg13_hv_pmos w=6.66u l=0.6u ng=1 m=1
XM27 pad net1 iovdd iovdd sg13_hv_pmos w=6.66u l=0.6u ng=1 m=1
XM28 iovdd net1 pad iovdd sg13_hv_pmos w=6.66u l=0.6u ng=1 m=1
XM29 pad net1 iovdd iovdd sg13_hv_pmos w=6.66u l=0.6u ng=1 m=1
XM30 iovdd net1 pad iovdd sg13_hv_pmos w=6.66u l=0.6u ng=1 m=1
XM31 pad net1 iovdd iovdd sg13_hv_pmos w=6.66u l=0.6u ng=1 m=1
XM32 iovdd net1 pad iovdd sg13_hv_pmos w=6.66u l=0.6u ng=1 m=1
XM33 pad net1 iovdd iovdd sg13_hv_pmos w=6.66u l=0.6u ng=1 m=1
XM34 iovdd net1 pad iovdd sg13_hv_pmos w=6.66u l=0.6u ng=1 m=1
XM35 pad net1 iovdd iovdd sg13_hv_pmos w=6.66u l=0.6u ng=1 m=1
XM36 iovdd net1 pad iovdd sg13_hv_pmos w=6.66u l=0.6u ng=1 m=1
XM37 pad net1 iovdd iovdd sg13_hv_pmos w=6.66u l=0.6u ng=1 m=1
XM38 iovdd net1 pad iovdd sg13_hv_pmos w=6.66u l=0.6u ng=1 m=1
XM39 pad net1 iovdd iovdd sg13_hv_pmos w=6.66u l=0.6u ng=1 m=1
XM40 iovdd net1 pad iovdd sg13_hv_pmos w=6.66u l=0.6u ng=1 m=1
XR1 net1 iovdd sub! rppd w=0.5e-6 l=12.9e-6 m=1 b=0
.ends

* expanding   symbol:  sg13g2_SecondaryProtection.sym # of pins=4
** sym_path: /foss/designs/IHP-Open-PDK/ihp-sg13g2/libs.ref/sg13g2_io/xschem/sg13g2_SecondaryProtection.sym
** sch_path: /foss/designs/IHP-Open-PDK/ihp-sg13g2/libs.ref/sg13g2_io/xschem/sg13g2_SecondaryProtection.sch
.subckt sg13g2_SecondaryProtection iovdd pad core iovss
*.iopin iovdd
*.iopin iovss
*.iopin core
*.iopin pad
XR1 pad core sub! rppd w=1e-6 l=2e-6 m=1 b=0
XD1 iovss core dantenna l=3.1u w=0.78u
XD2 core iovdd dpantenna l=0.78u w=4.98u
.ends

* expanding   symbol:  /foss/designs/PhaseInterpolator/Custom_std_cells/MUX_4_1.sym # of pins=9
** sym_path: /foss/designs/PhaseInterpolator/Custom_std_cells/MUX_4_1.sym
** sch_path: /foss/designs/PhaseInterpolator/Custom_std_cells/MUX_4_1.sch
.subckt MUX_4_1 VINA VINB VDD VOUT VS[1] VS[0] VINC VSS VIND VST
*.opin VOUT
*.iopin VDD
*.iopin VSS
*.ipin VINA
*.ipin VINB
*.ipin VINC
*.ipin VIND
*.ipin VS[1],VS[0]
*.ipin VST
x3 VDD VINC net2 VS[1] VIND VSS MUX_2_1
x4 VDD VINA net1 VS[0] VINB VSS MUX_2_1
x5 VDD net1 VOUT VST net2 VSS MUX_2_1
.ends

* expanding   symbol:  /foss/designs/PhaseInterpolator/Custom_std_cells/inv_PI.sym # of pins=4
** sym_path: /foss/designs/PhaseInterpolator/Custom_std_cells/inv_PI.sym
** sch_path: /foss/designs/PhaseInterpolator/Custom_std_cells/inv_PI.sch
.subckt inv_PI VDD VOUT VIN VSS
*.iopin VDD
*.iopin VSS
*.opin VOUT
*.ipin VIN
XM2 VOUT VIN VDD VDD sg13_lv_pmos w=0.45u l=0.13u ng=3 m=1
XM1 VOUT VIN VSS VSS sg13_lv_nmos w=0.3u l=0.13u ng=2 m=1
.ends

* expanding   symbol:  /foss/designs/PhaseInterpolator/Custom_std_cells/buff_PI_d16.sym # of pins=4
** sym_path: /foss/designs/PhaseInterpolator/Custom_std_cells/buff_PI_d16.sym
** sch_path: /foss/designs/PhaseInterpolator/Custom_std_cells/buff_PI_d16.sch
.subckt buff_PI_d16 VDD VOUT VIN VSS
*.ipin VIN
*.opin VOUT
*.iopin VDD
*.iopin VSS
x7 VDD net1 VIN VSS inv_PI_d2
x8 VDD net2 net1 VSS inv_PI_d4
x9 VDD net3 net2 VSS inv_PI_d8
x10 VDD VOUT net3 VSS inv_PI_d16
.ends

* expanding   symbol:  /foss/designs/PhaseInterpolator/2to4/dcvsl_variable.sym # of pins=7
** sym_path: /foss/designs/PhaseInterpolator/2to4/dcvsl_variable.sym
** sch_path: /foss/designs/PhaseInterpolator/2to4/dcvsl_variable.sch
.subckt dcvsl_variable VDD VOUTN VOUTP CTRL CLKN CLKP VSS
*.opin VOUTP
*.opin VOUTN
*.iopin VDD
*.ipin CLKN
*.ipin CLKP
*.ipin CTRL
*.iopin VSS
x2 VDD VOUTP VOUTDP VSS buff_PI_d16
x3 VDD VOUTN VOUTDN VSS buff_PI_d16
x1 CTRL VOUTDN VOUTDP VDD 2to4_decap
x4 VDD VOUTDN VOUTDP CTRL CLKN CLKP VSS 2to4_psdiff
.ends

* expanding   symbol:  /foss/designs/PhaseInterpolator/Custom_std_cells/nor_x3_custom.sym # of pins=6
** sym_path: /foss/designs/PhaseInterpolator/Custom_std_cells/nor_x3_custom.sym
** sch_path: /foss/designs/PhaseInterpolator/Custom_std_cells/nor_x3_custom.sch
.subckt nor_x3_custom VDD A B C OUT VSS
*.iopin VDD
*.iopin VSS
*.ipin B
*.ipin C
*.opin OUT
*.ipin A
XM1 OUT A VSS VSS sg13_lv_nmos w=0.15u l=0.13u ng=1 m=1
XM2 OUT C net1 VDD sg13_lv_pmos w=0.15u l=0.13u ng=1 m=1
XM3 OUT B VSS VSS sg13_lv_nmos w=0.15u l=0.13u ng=1 m=1
XM4 net1 B net2 VDD sg13_lv_pmos w=0.15u l=0.13u ng=1 m=1
XM5 net2 A VDD VDD sg13_lv_pmos w=0.15u l=0.13u ng=1 m=1
XM6 OUT C VSS VSS sg13_lv_nmos w=0.15u l=0.13u ng=1 m=1
.ends

* expanding   symbol:  /foss/designs/PhaseInterpolator/Custom_std_cells/nor_custom.sym # of pins=5
** sym_path: /foss/designs/PhaseInterpolator/Custom_std_cells/nor_custom.sym
** sch_path: /foss/designs/PhaseInterpolator/Custom_std_cells/nor_custom.sch
.subckt nor_custom VDD A OUT B VSS
*.iopin VDD
*.iopin VSS
*.ipin A
*.ipin B
*.opin OUT
XM1 OUT A VSS VSS sg13_lv_nmos w=0.15u l=0.13u ng=1 m=1
XM2 OUT B net1 VDD sg13_lv_pmos w=0.15u l=0.13u ng=1 m=1
XM3 OUT B VSS VSS sg13_lv_nmos w=0.15u l=0.13u ng=1 m=1
XM4 net1 A VDD VDD sg13_lv_pmos w=0.15u l=0.13u ng=1 m=1
.ends

* expanding   symbol:  /foss/designs/PhaseInterpolator/Custom_std_cells/nand_custom.sym # of pins=5
** sym_path: /foss/designs/PhaseInterpolator/Custom_std_cells/nand_custom.sym
** sch_path: /foss/designs/PhaseInterpolator/Custom_std_cells/nand_custom.sch
.subckt nand_custom VDD OUT A B VSS
*.iopin VDD
*.iopin VSS
*.ipin A
*.ipin B
*.opin OUT
XM1 OUT A net1 VSS sg13_lv_nmos w=0.15u l=0.13u ng=1 m=1
XM2 OUT A VDD VDD sg13_lv_pmos w=0.15u l=0.13u ng=1 m=1
XM3 net1 B VSS VSS sg13_lv_nmos w=0.15u l=0.13u ng=1 m=1
XM4 OUT B VDD VDD sg13_lv_pmos w=0.15u l=0.13u ng=1 m=1
.ends

* expanding   symbol:  /foss/designs/PhaseInterpolator/Custom_std_cells/and_custom.sym # of pins=5
** sym_path: /foss/designs/PhaseInterpolator/Custom_std_cells/and_custom.sym
** sch_path: /foss/designs/PhaseInterpolator/Custom_std_cells/and_custom.sch
.subckt and_custom VDD OUT A B VSS
*.ipin A
*.iopin VDD
*.opin OUT
*.iopin VSS
*.ipin B
x1 VDD OUT net1 VSS inv
x2 VDD net1 A B VSS nand_custom
.ends

* expanding   symbol:  /foss/designs/PhaseInterpolator/Custom_std_cells/or_custom.sym # of pins=5
** sym_path: /foss/designs/PhaseInterpolator/Custom_std_cells/or_custom.sym
** sch_path: /foss/designs/PhaseInterpolator/Custom_std_cells/or_custom.sch
.subckt or_custom VDD A OUT B VSS
*.iopin VDD
*.iopin VSS
*.opin OUT
*.ipin A
*.ipin B
x1 VDD A net1 B VSS nor_custom
x2 VDD OUT net1 VSS inv
.ends

* expanding   symbol:  /foss/designs/PhaseInterpolator/Custom_std_cells/nand_x3_custom.sym # of pins=6
** sym_path: /foss/designs/PhaseInterpolator/Custom_std_cells/nand_x3_custom.sym
** sch_path: /foss/designs/PhaseInterpolator/Custom_std_cells/nand_x3_custom.sch
.subckt nand_x3_custom VDD OUT A B C VSS
*.ipin A
*.ipin B
*.ipin C
*.iopin VSS
*.iopin VDD
*.opin OUT
XM2 OUT A VDD VDD sg13_lv_pmos w=0.15u l=0.13u ng=1 m=1
XM1 OUT B VDD VDD sg13_lv_pmos w=0.15u l=0.13u ng=1 m=1
XM3 OUT C VDD VDD sg13_lv_pmos w=0.15u l=0.13u ng=1 m=1
XM4 OUT A net1 VSS sg13_lv_nmos w=0.15u l=0.13u ng=1 m=1
XM5 net1 B net2 VSS sg13_lv_nmos w=0.15u l=0.13u ng=1 m=1
XM6 net2 C VSS VSS sg13_lv_nmos w=0.15u l=0.13u ng=1 m=1
.ends

* expanding   symbol:  /foss/designs/PhaseInterpolator/Custom_std_cells/xor_custom.sym # of pins=5
** sym_path: /foss/designs/PhaseInterpolator/Custom_std_cells/xor_custom.sym
** sch_path: /foss/designs/PhaseInterpolator/Custom_std_cells/xor_custom.sch
.subckt xor_custom VDD B VSS VOUT A
*.ipin A
*.ipin B
*.opin VOUT
*.iopin VDD
*.iopin VSS
*  x1 -  inv  IS MISSING !!!!
*  x3 -  tg_custom  IS MISSING !!!!
*  x2 -  inv_xor  IS MISSING !!!!
.ends

* expanding   symbol:  /foss/designs/PhaseInterpolator/Custom_std_cells/buff_d8.sym # of pins=4
** sym_path: /foss/designs/PhaseInterpolator/Custom_std_cells/buff_d8.sym
** sch_path: /foss/designs/PhaseInterpolator/Custom_std_cells/buff_d8.sch
.subckt buff_d8 VDD VOUT VIN VSS
*.ipin VIN
*.opin VOUT
*.iopin VDD
*.iopin VSS
x7 VDD net1 VIN VSS inv
x8 VDD net2 net1 VSS inv_d2
x9 VDD net3 net2 VSS inv_d4
x10 VDD VOUT net3 VSS inv_d8
.ends

* expanding   symbol:  sg13g2_LevelUpInv.sym # of pins=5
** sym_path: /foss/designs/IHP-Open-PDK/ihp-sg13g2/libs.ref/sg13g2_io/xschem/sg13g2_LevelUpInv.sym
** sch_path: /foss/designs/IHP-Open-PDK/ihp-sg13g2/libs.ref/sg13g2_io/xschem/sg13g2_LevelUpInv.sch
.subckt sg13g2_LevelUpInv iovdd vdd o i vss
*.iopin i
*.iopin vss
*.iopin vdd
*.iopin iovdd
*.iopin o
XM1 net1 i vss vss sg13_lv_nmos w=2.75u l=0.13u ng=1 m=1
XM2 net1 i vdd vdd sg13_lv_pmos w=4.75u l=0.13u ng=1 m=1
XM3 net2 net1 vss vss sg13_hv_nmos w=1.9u l=0.45u ng=1 m=1
XM4 net3 i vss vss sg13_hv_nmos w=1.9u l=0.45u ng=1 m=1
XM5 net2 net3 iovdd iovdd sg13_hv_pmos w=0.3u l=0.45u ng=1 m=1
XM6 net3 net2 iovdd iovdd sg13_hv_pmos w=0.3u l=0.45u ng=1 m=1
XM7 o net2 vss vss sg13_hv_nmos w=1.9u l=0.45u ng=1 m=1
XM8 o net2 iovdd iovdd sg13_hv_pmos w=3.9u l=0.45u ng=1 m=1
.ends

* expanding   symbol:  /foss/designs/PhaseInterpolator/Custom_std_cells/MUX_2_1.sym # of pins=6
** sym_path: /foss/designs/PhaseInterpolator/Custom_std_cells/MUX_2_1.sym
** sch_path: /foss/designs/PhaseInterpolator/Custom_std_cells/MUX_2_1.sch
.subckt MUX_2_1 VDD VINA VOUT VS VINB VSS
*.opin VOUT
*.ipin VINA
*.ipin VINB
*.ipin VS
*.iopin VDD
*.iopin VSS
x1 VOUT net1 VS net2 VDD VSS tg_custom
x2 VOUT VS net1 net3 VDD VSS tg_custom
x3 VDD net1 VS VSS inv
x4 VDD net2 VINA VSS inv_PI
x5 VDD net3 VINB VSS inv_PI
x6[3] VOUT VSS VDD net2 VDD VSS tg_custom
x6[2] VOUT VSS VDD net2 VDD VSS tg_custom
x6[1] VOUT VSS VDD net2 VDD VSS tg_custom
x6[0] VOUT VSS VDD net2 VDD VSS tg_custom
x7[3] VOUT VSS VDD net3 VDD VSS tg_custom
x7[2] VOUT VSS VDD net3 VDD VSS tg_custom
x7[1] VOUT VSS VDD net3 VDD VSS tg_custom
x7[0] VOUT VSS VDD net3 VDD VSS tg_custom
.ends

* expanding   symbol:  /foss/designs/PhaseInterpolator/Custom_std_cells/inv_PI_d2.sym # of pins=4
** sym_path: /foss/designs/PhaseInterpolator/Custom_std_cells/inv_PI_d2.sym
** sch_path: /foss/designs/PhaseInterpolator/Custom_std_cells/inv_PI_d2.sch
.subckt inv_PI_d2 VDD VOUT VIN VSS
*.ipin VIN
*.opin VOUT
*.iopin VDD
*.iopin VSS
x1[1] VDD VOUT VIN VSS inv_PI
x1[0] VDD VOUT VIN VSS inv_PI
.ends

* expanding   symbol:  /foss/designs/PhaseInterpolator/Custom_std_cells/inv_PI_d4.sym # of pins=4
** sym_path: /foss/designs/PhaseInterpolator/Custom_std_cells/inv_PI_d4.sym
** sch_path: /foss/designs/PhaseInterpolator/Custom_std_cells/inv_PI_d4.sch
.subckt inv_PI_d4 VDD VOUT VIN VSS
*.ipin VIN
*.opin VOUT
*.iopin VDD
*.iopin VSS
x1[1] VDD VOUT VIN VSS inv_PI_d2
x1[0] VDD VOUT VIN VSS inv_PI_d2
.ends

* expanding   symbol:  /foss/designs/PhaseInterpolator/Custom_std_cells/inv_PI_d8.sym # of pins=4
** sym_path: /foss/designs/PhaseInterpolator/Custom_std_cells/inv_PI_d8.sym
** sch_path: /foss/designs/PhaseInterpolator/Custom_std_cells/inv_PI_d8.sch
.subckt inv_PI_d8 VDD VOUT VIN VSS
*.ipin VIN
*.opin VOUT
*.iopin VDD
*.iopin VSS
x1[1] VDD VOUT VIN VSS inv_PI_d4
x1[0] VDD VOUT VIN VSS inv_PI_d4
.ends

* expanding   symbol:  /foss/designs/PhaseInterpolator/Custom_std_cells/inv_PI_d16.sym # of pins=4
** sym_path: /foss/designs/PhaseInterpolator/Custom_std_cells/inv_PI_d16.sym
** sch_path: /foss/designs/PhaseInterpolator/Custom_std_cells/inv_PI_d16.sch
.subckt inv_PI_d16 VDD VOUT VIN VSS
*.ipin VIN
*.opin VOUT
*.iopin VDD
*.iopin VSS
x1[1] VDD VOUT VIN VSS inv_PI_d8
x1[0] VDD VOUT VIN VSS inv_PI_d8
.ends

* expanding   symbol:  /foss/designs/PhaseInterpolator/2to4/2to4_decap.sym # of pins=4
** sym_path: /foss/designs/PhaseInterpolator/2to4/2to4_decap.sym
** sch_path: /foss/designs/PhaseInterpolator/2to4/2to4_decap.sch
.subckt 2to4_decap CTRL VOUTDN VOUTDP VDD
*.ipin CTRL
*.ipin VDD
*.ipin VOUTDN
*.ipin VOUTDP
XM10 CTRL VOUTDP CTRL VDD sg13_lv_pmos w=1u l=0.13u ng=1 m=36
XM9 CTRL VOUTDN CTRL VDD sg13_lv_pmos w=1u l=0.13u ng=1 m=36
.ends

* expanding   symbol:  /foss/designs/PhaseInterpolator/2to4/2to4_psdiff.sym # of pins=7
** sym_path: /foss/designs/PhaseInterpolator/2to4/2to4_psdiff.sym
** sch_path: /foss/designs/PhaseInterpolator/2to4/2to4_psdiff.sch
.subckt 2to4_psdiff VDD VOUTDN VOUTDP CTRL CLKN CLKP VSS
*.iopin VSS
*.ipin CLKP
*.ipin CLKN
*.iopin VDD
*.ipin CTRL
*.opin VOUTDN
*.opin VOUTDP
XM1 VOUTDN CLKP VSS VSS sg13_lv_nmos w=0.15u l=0.13u ng=1 m=33
XM2 VOUTDP CLKN VSS VSS sg13_lv_nmos w=0.15u l=0.13u ng=1 m=33
XM3 net1 CTRL VOUTDN VSS sg13_lv_nmos w=0.15u l=0.13u ng=1 m=2
XM4 net2 CTRL VOUTDP VSS sg13_lv_nmos w=0.15u l=0.13u ng=1 m=2
XM6 VOUTDP net1 VDD VDD sg13_lv_pmos w=0.15u l=0.13u ng=1 m=10
XM5 VOUTDN net2 VDD VDD sg13_lv_pmos w=0.15u l=0.13u ng=1 m=10
XM7 VOUTDN VSS VDD VDD sg13_lv_pmos w=0.15u l=0.13u ng=1 m=20
XM8 VOUTDP VSS VDD VDD sg13_lv_pmos w=0.15u l=0.13u ng=1 m=20
.ends

* expanding   symbol:  /foss/designs/PhaseInterpolator/Custom_std_cells/inv_d2.sym # of pins=4
** sym_path: /foss/designs/PhaseInterpolator/Custom_std_cells/inv_d2.sym
** sch_path: /foss/designs/PhaseInterpolator/Custom_std_cells/inv_d2.sch
.subckt inv_d2 VDD VOUT VIN VSS
*.ipin VIN
*.opin VOUT
*.iopin VDD
*.iopin VSS
x1[1] VDD VOUT VIN VSS inv
x1[0] VDD VOUT VIN VSS inv
.ends

* expanding   symbol:  /foss/designs/PhaseInterpolator/Custom_std_cells/inv_d4.sym # of pins=4
** sym_path: /foss/designs/PhaseInterpolator/Custom_std_cells/inv_d4.sym
** sch_path: /foss/designs/PhaseInterpolator/Custom_std_cells/inv_d4.sch
.subckt inv_d4 VDD VOUT VIN VSS
*.ipin VIN
*.opin VOUT
*.iopin VDD
*.iopin VSS
x1[1] VDD VOUT VIN VSS inv_d2
x1[0] VDD VOUT VIN VSS inv_d2
.ends

* expanding   symbol:  /foss/designs/PhaseInterpolator/Custom_std_cells/inv_d8.sym # of pins=4
** sym_path: /foss/designs/PhaseInterpolator/Custom_std_cells/inv_d8.sym
** sch_path: /foss/designs/PhaseInterpolator/Custom_std_cells/inv_d8.sch
.subckt inv_d8 VDD VOUT VIN VSS
*.ipin VIN
*.opin VOUT
*.iopin VDD
*.iopin VSS
x1[1] VDD VOUT VIN VSS inv_d4
x1[0] VDD VOUT VIN VSS inv_d4
.ends

* expanding   symbol:  /foss/designs/PhaseInterpolator/Custom_std_cells/tg_custom.sym # of pins=6
** sym_path: /foss/designs/PhaseInterpolator/Custom_std_cells/tg_custom.sym
** sch_path: /foss/designs/PhaseInterpolator/Custom_std_cells/tg_custom.sch
.subckt tg_custom VOUT VSN VSP VIN VBP VBN
*.iopin VIN
*.iopin VSN
*.iopin VOUT
*.iopin VSP
*.iopin VBN
*.iopin VBP
XM1 VOUT VSN VIN VBN sg13_lv_nmos w=0.15u l=0.13u ng=1 m=1
XM2 VOUT VSP VIN VBP sg13_lv_pmos w=0.3u l=0.13u ng=2 m=1
.ends

.GLOBAL GND
.end
