* Extracted by KLayout with SG13G2 LVS runset on : 04/01/2026 18:26

.SUBCKT inv VDD VOUT
M$1 \$1 \$4 VOUT \$1 sg13_lv_nmos L=0.13u W=0.15u AS=0.1005p AD=0.1005p
+ PS=1.34u PD=1.34u
M$2 VDD \$4 VOUT VDD sg13_lv_pmos L=0.13u W=0.15u AS=0.1005p AD=0.1005p
+ PS=1.34u PD=1.34u
.ENDS inv
