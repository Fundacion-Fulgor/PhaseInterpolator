* Extracted by KLayout with SG13G2 LVS runset on : 23/02/2026 19:49

.SUBCKT inv_PI_d2 VSS VDD|VOUT VIN
X$1 VIN VSS VDD|VOUT inv_PI
X$2 VIN VSS VDD|VOUT inv_PI
M$1 VDD|VOUT VIN VDD|VOUT VDD|VOUT sg13_lv_pmos L=0.13u W=0.9u AS=0.378p
+ AD=0.378p PS=5.04u PD=5.04u
.ENDS inv_PI_d2

.SUBCKT inv_PI VIN VSS VOUT
M$1 VSS VIN VOUT VSS sg13_lv_nmos L=0.13u W=0.3u AS=0.156p AD=0.156p PS=2.08u
+ PD=2.08u
.ENDS inv_PI
