* Extracted by KLayout with SG13G2 LVS runset on : 01/03/2026 18:47

.SUBCKT inv_PI_d2 VSS VIN VOUT VDD
X$1 VSS VIN VOUT VDD inv_PI
X$2 VSS VIN VOUT VDD inv_PI
.ENDS inv_PI_d2

.SUBCKT inv_PI VSS VIN VOUT VDD
M$1 VSS VIN VOUT VSS sg13_lv_nmos L=0.13u W=0.3u AS=0.156p AD=0.156p PS=2.08u
+ PD=2.08u
M$3 VDD VIN VOUT VDD sg13_lv_pmos L=0.13u W=0.45u AS=0.2115p AD=0.2115p
+ PS=2.82u PD=2.82u
.ENDS inv_PI
