* Extracted by KLayout with SG13G2 LVS runset on : 20/01/2026 04:38

.SUBCKT buff_PI_d16 VDD|VSS VIN VOUT
X$1 VDD|VSS VDD|VSS VOUT VDD|VSS inv_PI_d16
X$2 VDD|VSS \$4 VDD|VSS VDD|VSS inv_PI_d8
X$3 VDD|VSS VIN \$3 VDD|VSS inv_PI_d2
X$4 \$4 VDD|VSS \$3 VDD|VSS inv_PI_d4
.ENDS buff_PI_d16

.SUBCKT inv_PI_d16 VDD VSS VOUT VIN
X$1 VOUT VIN VSS VDD inv_PI_d8
X$2 VOUT VIN VSS VDD inv_PI_d8
.ENDS inv_PI_d16

.SUBCKT inv_PI_d8 VOUT VIN VSS VDD
X$1 VOUT VSS VIN VDD inv_PI_d4
X$2 VOUT VSS VIN VDD inv_PI_d4
.ENDS inv_PI_d8

.SUBCKT inv_PI_d4 VOUT VSS VIN VDD
X$1 VSS VIN VOUT VDD inv_PI_d2
X$2 VSS VIN VOUT VDD inv_PI_d2
.ENDS inv_PI_d4

.SUBCKT inv_PI_d2 VSS VIN VOUT VDD
M$1 VSS VIN VOUT VSS sg13_lv_nmos L=0.13u W=0.6u AS=0.267p AD=0.267p PS=3.56u
+ PD=3.56u
M$5 VDD VIN VOUT VDD sg13_lv_pmos L=0.13u W=0.9u AS=0.378p AD=0.378p PS=5.04u
+ PD=5.04u
.ENDS inv_PI_d2
