* Extracted by KLayout with SG13G2 LVS runset on : 02/03/2026 14:36

.SUBCKT reg_v2 VSS VDD CLK D Q
X$1 VDD VSS CLK \$7 \$8 \$4 tg_custom
X$2 VDD D VSS \$4 inv
X$3 VDD \$6 VSS \$15 inv
X$4 VDD \$8 VSS \$6 inv
X$5 VDD VSS \$7 CLK \$8 \$15 tg_custom
X$6 VDD CLK VSS \$7 inv
X$7 VDD Q VSS \$16 inv
X$8 VDD VSS \$7 CLK \$9 \$3 tg_custom
X$9 VDD VSS CLK \$7 \$9 \$16 tg_custom
X$10 VDD \$6 VSS \$3 inv
X$11 VDD \$9 VSS Q inv
.ENDS reg_v2

.SUBCKT inv VDD VIN VSS VOUT
M$1 VSS VIN VOUT VSS sg13_lv_nmos L=0.13u W=0.15u AS=0.1005p AD=0.1005p
+ PS=1.34u PD=1.34u
M$2 VDD VIN VOUT VDD sg13_lv_pmos L=0.13u W=0.15u AS=0.1005p AD=0.1005p
+ PS=1.34u PD=1.34u
.ENDS inv

.SUBCKT tg_custom VBP VBN VSP VSN VOUT VIN
M$1 VIN VSN VOUT VBN sg13_lv_nmos L=0.13u W=0.15u AS=0.1005p AD=0.1005p
+ PS=1.34u PD=1.34u
M$2 VIN VSP VOUT VBP sg13_lv_pmos L=0.13u W=0.3u AS=0.156p AD=0.156p PS=2.08u
+ PD=2.08u
.ENDS tg_custom
