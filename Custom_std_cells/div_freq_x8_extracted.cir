* Extracted by KLayout with SG13G2 LVS runset on : 02/03/2026 22:33

.SUBCKT div_freq_x8 VSS VDD VINPI VOUT
X$1 \$2 VSS VINPI VDD div_freq_x2
X$2 VOUT VSS \$3 VDD div_freq_x2
X$3 \$3 VSS \$2 VDD div_freq_x2
.ENDS div_freq_x8

.SUBCKT div_freq_x2 CLKOUT VSS CLKIN VDD
X$1 VDD VSS CLKIN \$2 CLKOUT reg_v2
X$2 VSS CLKOUT \$2 VDD inv
.ENDS div_freq_x2

.SUBCKT reg_v2 VDD VSS CLK D Q
X$1 VSS \$8 \$7 \$3 CLK VDD tg_custom
X$2 VSS D \$3 VDD inv
X$3 VSS Q \$25 VDD inv
X$4 VSS \$8 \$6 VDD inv
X$5 VSS \$9 \$7 \$25 CLK VDD tg_custom
X$6 VSS \$6 \$24 VDD inv
X$7 VSS \$8 CLK \$24 \$7 VDD tg_custom
X$8 VSS CLK \$7 VDD inv
X$9 VSS \$9 Q VDD inv
X$10 VSS \$9 CLK \$4 \$7 VDD tg_custom
X$11 VSS \$6 \$4 VDD inv
.ENDS reg_v2

.SUBCKT inv VSS VIN VOUT VDD
M$1 VSS VIN VOUT VSS sg13_lv_nmos L=0.13u W=0.15u AS=0.1005p AD=0.1005p
+ PS=1.34u PD=1.34u
M$2 VDD VIN VOUT VDD sg13_lv_pmos L=0.13u W=0.15u AS=0.1005p AD=0.1005p
+ PS=1.34u PD=1.34u
.ENDS inv

.SUBCKT tg_custom VBN VOUT VSN VIN VSP VBP
M$1 VIN VSN VOUT VBN sg13_lv_nmos L=0.13u W=0.15u AS=0.1005p AD=0.1005p
+ PS=1.34u PD=1.34u
M$2 VIN VSP VOUT VBP sg13_lv_pmos L=0.13u W=0.3u AS=0.156p AD=0.156p PS=2.08u
+ PD=2.08u
.ENDS tg_custom
