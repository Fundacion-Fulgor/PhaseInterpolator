* NGSPICE file created from inv.ext - technology: ihp-sg13g2

.subckt inv VDD VSS VIN VOUT
X0 VOUT.t0 VIN.t0 VSS.t1 VSS.t0 sg13_lv_nmos ad=0.1005p pd=1.34u as=0.1005p ps=1.34u w=0.15u l=0.13u
X1 VOUT.t1 VIN.t0 VDD.t1 VDD.t0 sg13_lv_pmos ad=0.1005p pd=1.34u as=0.1005p ps=1.34u w=0.15u l=0.13u
R0 VIN VIN.t0 15.0555
R1 VSS.n0 VSS.t0 1295.57
R2 VSS.n0 VSS.t1 17.3133
R3 VSS VSS.n0 0.141056
R4 VOUT.n0 VOUT.t1 17.8118
R5 VOUT.n0 VOUT.t0 17.0005
R6 VOUT VOUT.n0 0.089875
R7 VDD.n0 VDD.t1 17.3167
R8 VDD.n0 VDD.t0 17.0294
R9 VDD VDD.n0 0.0942037
C0 VDD VIN 0.07589f
C1 VDD VOUT 0.04921f
C2 VOUT VIN 0.04947f
C3 VOUT VSS 0.12019f
C4 VIN VSS 0.23352f
C5 VDD VSS 0.15733f
.ends
