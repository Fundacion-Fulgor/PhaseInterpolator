* Extracted by KLayout with SG13G2 LVS runset on : 27/02/2026 21:26

.SUBCKT inv_d4 VOUT VSS VDD VIN
X$1 VIN VSS VDD VOUT inv_d2
X$2 VIN VSS VDD VOUT inv_d2
.ENDS inv_d4

.SUBCKT inv_d2 VIN VSS VDD VOUT
M$1 VSS VIN VOUT VSS sg13_lv_nmos L=0.13u W=0.3u AS=0.156p AD=0.156p PS=2.08u
+ PD=2.08u
M$3 VDD VIN VOUT VDD sg13_lv_pmos L=0.13u W=0.3u AS=0.156p AD=0.156p PS=2.08u
+ PD=2.08u
.ENDS inv_d2
