* Extracted by KLayout with SG13G2 LVS runset on : 11/01/2026 21:28

.SUBCKT inv_d8 VSS VIN VOUT VDD
X$1 VSS VIN VOUT VDD inv_d4
X$2 VSS VIN VOUT VDD inv_d4
.ENDS inv_d8

.SUBCKT inv_d4 VSS VIN VOUT VDD
X$1 VSS VIN VOUT VDD inv_d2
X$2 VSS VIN VOUT VDD inv_d2
.ENDS inv_d4

.SUBCKT inv_d2 VSS VIN VOUT VDD
M$1 VSS VIN VOUT VSS sg13_lv_nmos L=0.13u W=0.3u AS=0.156p AD=0.156p PS=2.08u
+ PD=2.08u
M$3 VDD VIN VOUT VDD sg13_lv_pmos L=0.13u W=0.3u AS=0.156p AD=0.156p PS=2.08u
+ PD=2.08u
.ENDS inv_d2
