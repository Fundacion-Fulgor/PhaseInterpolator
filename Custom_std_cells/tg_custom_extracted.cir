* Extracted by KLayout with SG13G2 LVS runset on : 01/03/2026 17:39

.SUBCKT tg_custom VBP VBN VSP VSN VOUT VIN
M$1 VIN VSP VOUT VBP sg13_lv_pmos L=0.13u W=0.3u AS=0.156p AD=0.156p PS=2.08u
+ PD=2.08u
M$3 VIN VSN VOUT VBN sg13_lv_nmos L=0.13u W=0.15u AS=0.1005p AD=0.1005p
+ PS=1.34u PD=1.34u
.ENDS tg_custom
