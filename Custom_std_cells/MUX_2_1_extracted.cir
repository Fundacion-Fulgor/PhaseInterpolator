* Extracted by KLayout with SG13G2 LVS runset on : 03/03/2026 19:36

.SUBCKT MUX_2_1 VSS VOUT VS VINB VDD VINA
X$1 VSS \$5 \$8 \$14 \$10 VDD tg_custom
X$2 VSS \$5 \$8 \$14 \$10 VDD tg_custom
X$3 VSS VDD \$8 tiel_custom
X$4 VSS \$5 \$8 \$14 \$10 VDD tg_custom
X$5 VSS \$5 \$8 \$14 \$10 VDD tg_custom
X$6 VSS \$5 \$8 \$14 \$10 VDD tg_custom
X$7 VSS VOUT \$10 \$5 \$8 VDD tg_custom
X$8 VSS \$5 \$8 \$14 \$10 VDD tg_custom
X$9 VDD VINB VSS \$14 inv_PI
X$10 VSS \$5 VS \$14 \$18 VDD tg_custom
X$11 VSS \$19 \$8 \$21 \$10 VDD tg_custom
X$12 VSS \$19 \$8 \$21 \$10 VDD tg_custom
X$13 VSS VOUT \$10 \$19 \$8 VDD tg_custom
X$14 VSS \$19 \$8 \$21 \$10 VDD tg_custom
X$15 VSS \$19 \$8 \$21 \$10 VDD tg_custom
X$16 VSS \$19 \$8 \$21 \$10 VDD tg_custom
X$17 VSS \$19 \$8 \$21 \$10 VDD tg_custom
X$18 VSS VDD \$10 tieh_custom
X$19 VSS \$19 \$18 \$21 VS VDD tg_custom
X$20 VDD VS VSS \$18 inv
X$21 VDD VINA VSS \$21 inv_PI
.ENDS MUX_2_1

.SUBCKT tieh_custom VSS VDD VOUT
M$1 VSS \$3 \$3 VSS sg13_lv_nmos L=0.13u W=0.15u AS=0.1005p AD=0.1005p PS=1.34u
+ PD=1.34u
M$2 VDD \$3 VOUT VDD sg13_lv_pmos L=0.13u W=0.15u AS=0.1005p AD=0.1005p
+ PS=1.34u PD=1.34u
.ENDS tieh_custom

.SUBCKT tiel_custom VSS VDD VOUT
M$1 VSS \$3 VOUT VSS sg13_lv_nmos L=0.13u W=0.15u AS=0.1005p AD=0.1005p
+ PS=1.34u PD=1.34u
M$2 VDD \$3 \$3 VDD sg13_lv_pmos L=0.13u W=0.15u AS=0.1005p AD=0.1005p PS=1.34u
+ PD=1.34u
.ENDS tiel_custom

.SUBCKT tg_custom VBN VOUT VSN VIN VSP VBP
M$1 VIN VSN VOUT VBN sg13_lv_nmos L=0.13u W=0.15u AS=0.1005p AD=0.1005p
+ PS=1.34u PD=1.34u
M$2 VIN VSP VOUT VBP sg13_lv_pmos L=0.13u W=0.3u AS=0.156p AD=0.156p PS=2.08u
+ PD=2.08u
.ENDS tg_custom

.SUBCKT inv_PI VDD VIN VSS VOUT
M$1 VSS VIN VOUT VSS sg13_lv_nmos L=0.13u W=0.3u AS=0.156p AD=0.156p PS=2.08u
+ PD=2.08u
M$3 VDD VIN VOUT VDD sg13_lv_pmos L=0.13u W=0.45u AS=0.2115p AD=0.2115p
+ PS=2.82u PD=2.82u
.ENDS inv_PI

.SUBCKT inv VDD VIN VSS VOUT
M$1 VSS VIN VOUT VSS sg13_lv_nmos L=0.13u W=0.15u AS=0.1005p AD=0.1005p
+ PS=1.34u PD=1.34u
M$2 VDD VIN VOUT VDD sg13_lv_pmos L=0.13u W=0.15u AS=0.1005p AD=0.1005p
+ PS=1.34u PD=1.34u
.ENDS inv
