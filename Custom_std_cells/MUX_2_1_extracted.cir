* Extracted by KLayout with SG13G2 LVS runset on : 24/01/2026 20:47

.SUBCKT MUX_2_1 VSS VDD VOUT VINB VS VINA
X$1 VDD VINB VSS \$11 inv_PI
X$4 VDD VSS \$20 VOUT VDD VSS tg_custom
X$5 VDD VSS \$20 VOUT VDD VSS tg_custom
X$6 VDD VSS \$20 VOUT VDD VSS tg_custom
X$7 VDD VSS \$11 VOUT VDD VSS tg_custom
X$8 VDD VSS \$20 VOUT VDD VSS tg_custom
X$9 VDD VSS \$11 VOUT VDD VSS tg_custom
X$10 VDD VSS \$11 VOUT VDD VSS tg_custom
X$11 VDD VSS \$11 VOUT VDD VSS tg_custom
X$19 VDD VSS \$20 VOUT VS \$8 tg_custom
X$38 VDD VSS \$11 VOUT \$8 VS tg_custom
X$51 VDD VINA VSS \$20 inv_PI
X$54 VDD VS VSS \$8 inv
.ENDS MUX_2_1

.SUBCKT inv_PI VDD VIN VSS VOUT
M$1 VSS VIN VOUT VSS sg13_lv_nmos L=0.13u W=0.3u AS=0.156p AD=0.156p PS=2.08u
+ PD=2.08u
M$3 VDD VIN VOUT VDD sg13_lv_pmos L=0.13u W=0.45u AS=0.2115p AD=0.2115p
+ PS=2.82u PD=2.82u
.ENDS inv_PI

.SUBCKT inv VDD VIN VSS VOUT
M$1 VSS VIN VOUT VSS sg13_lv_nmos L=0.13u W=0.15u AS=0.1005p AD=0.1005p
+ PS=1.34u PD=1.34u
M$2 VDD VIN VOUT VDD sg13_lv_pmos L=0.13u W=0.15u AS=0.1005p AD=0.1005p
+ PS=1.34u PD=1.34u
.ENDS inv

.SUBCKT tg_custom VBP VBN VIN VOUT VSP VSN
M$1 VIN VSN VOUT VBN sg13_lv_nmos L=0.13u W=0.15u AS=0.1005p AD=0.1005p
+ PS=1.34u PD=1.34u
M$2 VIN VSP VOUT VBP sg13_lv_pmos L=0.13u W=0.3u AS=0.156p AD=0.156p PS=2.08u
+ PD=2.08u
.ENDS tg_custom
