* Extracted by KLayout with SG13G2 LVS runset on : 05/02/2026 16:08

.SUBCKT inv_d2 VIN VSS VDD VOUT
M$1 VSS VIN VOUT VSS sg13_lv_nmos L=0.13u W=0.3u AS=0.156p AD=0.156p PS=2.08u
+ PD=2.08u
M$3 VDD VIN VOUT VDD sg13_lv_pmos L=0.13u W=0.3u AS=0.156p AD=0.156p PS=2.08u
+ PD=2.08u
.ENDS inv_d2
