* Extracted by KLayout with SG13G2 LVS runset on : 04/03/2026 20:38

.SUBCKT xor_custom A B VOUT VSS VDD
X$1 VSS A \$2 VOUT B VDD tg_custom
X$2 VDD A VSS \$2 VOUT B inv_xor
X$3 VSS B \$2 VDD inv
.ENDS xor_custom

.SUBCKT inv_xor VBP VIN VBN VSS VOUT VDD
M$1 VSS VIN VOUT VBN sg13_lv_nmos L=0.13u W=0.15u AS=0.1005p AD=0.1005p
+ PS=1.34u PD=1.34u
M$2 VDD VIN VOUT VBP sg13_lv_pmos L=0.13u W=0.15u AS=0.1005p AD=0.1005p
+ PS=1.34u PD=1.34u
.ENDS inv_xor

.SUBCKT tg_custom VBN VOUT VSN VIN VSP VBP
M$1 VIN VSN VOUT VBN sg13_lv_nmos L=0.13u W=0.15u AS=0.1005p AD=0.1005p
+ PS=1.34u PD=1.34u
M$2 VIN VSP VOUT VBP sg13_lv_pmos L=0.13u W=0.3u AS=0.156p AD=0.156p PS=2.08u
+ PD=2.08u
.ENDS tg_custom

.SUBCKT inv VSS VIN VOUT VDD
M$1 VSS VIN VOUT VSS sg13_lv_nmos L=0.13u W=0.15u AS=0.1005p AD=0.1005p
+ PS=1.34u PD=1.34u
M$2 VDD VIN VOUT VDD sg13_lv_pmos L=0.13u W=0.15u AS=0.1005p AD=0.1005p
+ PS=1.34u PD=1.34u
.ENDS inv
