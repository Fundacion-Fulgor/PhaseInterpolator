* Extracted by KLayout with SG13G2 LVS runset on : 19/01/2026 22:58

.SUBCKT xor_custom VOUT VSS A B VDD
X$1 VDD VSS VOUT A B \$5 tg_custom
X$2 VSS VDD A VOUT B \$5 inv_xor
X$3 VDD B VSS \$5 inv
.ENDS xor_custom

.SUBCKT inv_xor VBN VBP VIN VOUT VDD VSS
M$1 VSS VIN VOUT VBN sg13_lv_nmos L=0.13u W=0.15u AS=0.1005p AD=0.1005p
+ PS=1.34u PD=1.34u
M$2 VDD VIN VOUT VBP sg13_lv_pmos L=0.13u W=0.15u AS=0.1005p AD=0.1005p
+ PS=1.34u PD=1.34u
.ENDS inv_xor

.SUBCKT tg_custom VBP VBN VIN VOUT VSP VSN
M$1 VIN VSN VOUT VBN sg13_lv_nmos L=0.13u W=0.15u AS=0.1005p AD=0.1005p
+ PS=1.34u PD=1.34u
M$2 VIN VSP VOUT VBP sg13_lv_pmos L=0.13u W=0.3u AS=0.156p AD=0.156p PS=2.08u
+ PD=2.08u
.ENDS tg_custom

.SUBCKT inv VDD VIN VSS VOUT
M$1 VSS VIN VOUT VSS sg13_lv_nmos L=0.13u W=0.15u AS=0.1005p AD=0.1005p
+ PS=1.34u PD=1.34u
M$2 VDD VIN VOUT VDD sg13_lv_pmos L=0.13u W=0.15u AS=0.1005p AD=0.1005p
+ PS=1.34u PD=1.34u
.ENDS inv
