* Extracted by KLayout with SG13G2 LVS runset on : 28/02/2026 19:29

.SUBCKT nor_x3_custom VDD VSS C B A OUT
M$1 VSS A OUT VSS sg13_lv_nmos L=0.13u W=0.15u AS=0.1005p AD=0.0555p PS=1.34u
+ PD=0.74u
M$2 OUT B VSS VSS sg13_lv_nmos L=0.13u W=0.15u AS=0.0555p AD=0.0555p PS=0.74u
+ PD=0.74u
M$3 VSS C OUT VSS sg13_lv_nmos L=0.13u W=0.15u AS=0.0555p AD=0.1005p PS=0.74u
+ PD=1.34u
M$4 VDD A \$9 VDD sg13_lv_pmos L=0.13u W=0.15u AS=0.1005p AD=0.0555p PS=1.34u
+ PD=0.74u
M$5 \$9 B \$8 VDD sg13_lv_pmos L=0.13u W=0.15u AS=0.0555p AD=0.0555p PS=0.74u
+ PD=0.74u
M$6 \$8 C OUT VDD sg13_lv_pmos L=0.13u W=0.15u AS=0.0555p AD=0.1005p PS=0.74u
+ PD=1.34u
.ENDS nor_x3_custom
