* Extracted by KLayout with SG13G2 LVS runset on : 28/02/2026 18:46

.SUBCKT and_x3_custom VSS B A C OUT VDD
X$1 VDD \$1 VSS OUT inv
X$2 B C VDD VSS A \$1 nand_x3_custom
.ENDS and_x3_custom

.SUBCKT nand_x3_custom B C VDD VSS A OUT
M$1 OUT A \$9 VSS sg13_lv_nmos L=0.13u W=0.15u AS=0.1005p AD=0.0555p PS=1.34u
+ PD=0.74u
M$2 \$9 B \$8 VSS sg13_lv_nmos L=0.13u W=0.15u AS=0.0555p AD=0.0555p PS=0.74u
+ PD=0.74u
M$3 \$8 C VSS VSS sg13_lv_nmos L=0.13u W=0.15u AS=0.0555p AD=0.1005p PS=0.74u
+ PD=1.34u
M$4 VDD A OUT VDD sg13_lv_pmos L=0.13u W=0.15u AS=0.1005p AD=0.0555p PS=1.34u
+ PD=0.74u
M$5 OUT B VDD VDD sg13_lv_pmos L=0.13u W=0.15u AS=0.0555p AD=0.0555p PS=0.74u
+ PD=0.74u
M$6 VDD C OUT VDD sg13_lv_pmos L=0.13u W=0.15u AS=0.0555p AD=0.1005p PS=0.74u
+ PD=1.34u
.ENDS nand_x3_custom

.SUBCKT inv VDD VIN VSS VOUT
M$1 VSS VIN VOUT VSS sg13_lv_nmos L=0.13u W=0.15u AS=0.1005p AD=0.1005p
+ PS=1.34u PD=1.34u
M$2 VDD VIN VOUT VDD sg13_lv_pmos L=0.13u W=0.15u AS=0.1005p AD=0.1005p
+ PS=1.34u PD=1.34u
.ENDS inv
