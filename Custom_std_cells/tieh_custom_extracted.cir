* Extracted by KLayout with SG13G2 LVS runset on : 02/03/2026 15:19

.SUBCKT tieh_custom VSS VDD VOUT
M$1 VDD \$3 VOUT VDD sg13_lv_pmos L=0.13u W=0.15u AS=0.1005p AD=0.1005p
+ PS=1.34u PD=1.34u
M$2 VSS \$3 \$3 VSS sg13_lv_nmos L=0.13u W=0.15u AS=0.1005p AD=0.1005p PS=1.34u
+ PD=1.34u
.ENDS tieh_custom
