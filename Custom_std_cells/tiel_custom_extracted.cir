* Extracted by KLayout with SG13G2 LVS runset on : 02/03/2026 15:52

.SUBCKT tiel_custom VSS VDD VOUT
M$1 VSS \$3 VOUT VSS sg13_lv_nmos L=0.13u W=0.15u AS=0.1005p AD=0.1005p
+ PS=1.34u PD=1.34u
M$2 VDD \$3 \$3 VDD sg13_lv_pmos L=0.13u W=0.15u AS=0.1005p AD=0.1005p PS=1.34u
+ PD=1.34u
.ENDS tiel_custom
