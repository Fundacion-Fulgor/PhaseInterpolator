** sch_path: /foss/designs/PhaseInterpolator/2to4/2to4_decap.sch
**.subckt 2to4_decap CTRL VDD VOUTDN VOUTDP
*.ipin CTRL
*.ipin VDD
*.ipin VOUTDN
*.ipin VOUTDP
XM10 CTRL VOUTDP CTRL VDD sg13_lv_pmos w=1u l=0.13u ng=1 m=36
XM9 CTRL VOUTDN CTRL VDD sg13_lv_pmos w=1u l=0.13u ng=1 m=36
**.ends
.end
