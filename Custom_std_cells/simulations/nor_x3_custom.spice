** sch_path: /foss/designs/PhaseInterpolator/Custom_std_cells/nor_x3_custom.sch
.subckt nor_x3_custom VDD A B C OUT VSS
*.PININFO VDD:B VSS:B B:I C:I OUT:O A:I
M1 OUT A VSS VSS sg13_lv_nmos w=0.15u l=0.13u ng=1 m=1
M2 OUT C net1 VDD sg13_lv_pmos w=0.15u l=0.13u ng=1 m=1
M3 OUT B VSS VSS sg13_lv_nmos w=0.15u l=0.13u ng=1 m=1
M4 net1 B net2 VDD sg13_lv_pmos w=0.15u l=0.13u ng=1 m=1
M5 net2 A VDD VDD sg13_lv_pmos w=0.15u l=0.13u ng=1 m=1
M6 OUT C VSS VSS sg13_lv_nmos w=0.15u l=0.13u ng=1 m=1
.ends
