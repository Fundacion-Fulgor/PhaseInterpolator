** sch_path: /foss/designs/PhaseInterpolator/Custom_std_cells/div_freq_x8.sch
.subckt div_freq_x8 VDD VINPI VOUT VSS
*.PININFO VDD:B VSS:B VINPI:B VOUT:O
x7 VDD VSS net1 VINPI div_freq_x2
x8 VDD VSS net2 net1 div_freq_x2
x9 VDD VSS VOUT net2 div_freq_x2
.ends

* expanding   symbol:  /foss/designs/PhaseInterpolator/Custom_std_Cells/div_freq_x2.sym # of pins=4
** sym_path: /foss/designs/PhaseInterpolator/Custom_std_Cells/div_freq_x2.sym
** sch_path: /foss/designs/PhaseInterpolator/Custom_std_Cells/div_freq_x2.sch
.subckt div_freq_x2 VDD VSS CLKOUT CLKIN
*.PININFO VDD:B VSS:B CLKIN:I CLKOUT:O
x1 VDD CLKIN VSS CLKOUT net1 reg_v2
x4 VDD net1 CLKOUT VSS inv
.ends

* expanding   symbol:  /foss/designs/PhaseInterpolator/Custom_std_Cells/reg_v2.sym # of pins=5
** sym_path: /foss/designs/PhaseInterpolator/Custom_std_Cells/reg_v2.sym
** sch_path: /foss/designs/PhaseInterpolator/Custom_std_Cells/reg_v2.sch
.subckt reg_v2 VDD CLK VSS Q D
*.PININFO VDD:B VSS:B CLK:I D:I Q:O
x3 net7 CLK CLK_B net2 VDD VSS tg_custom
x9 VDD CLK_B CLK VSS inv
x4 VDD net2 net1 VSS inv
x8 VDD net4 D VSS inv
x11 VDD net3 Q VSS inv
x10 VDD net5 net1 VSS inv
x2 net7 CLK_B CLK net4 VDD VSS tg_custom
x6 net6 CLK_B CLK net3 VDD VSS tg_custom
x7 net6 CLK CLK_B net5 VDD VSS tg_custom
x5 VDD net1 net7 VSS inv
x1 VDD Q net6 VSS inv
.ends

* expanding   symbol:  /foss/designs/PhaseInterpolator/Custom_std_Cells/inv.sym # of pins=4
** sym_path: /foss/designs/PhaseInterpolator/Custom_std_Cells/inv.sym
** sch_path: /foss/designs/PhaseInterpolator/Custom_std_Cells/inv.sch
.subckt inv VDD VOUT VIN VSS
*.PININFO VDD:B VSS:B VOUT:O VIN:I
M2 VOUT VIN VDD VDD sg13_lv_pmos w=0.15u l=0.13u ng=1 m=1
M1 VOUT VIN VSS VSS sg13_lv_nmos w=0.15u l=0.13u ng=1 m=1
.ends

* expanding   symbol:  /foss/designs/PhaseInterpolator/Custom_std_Cells/tg_custom.sym # of pins=6
** sym_path: /foss/designs/PhaseInterpolator/Custom_std_Cells/tg_custom.sym
** sch_path: /foss/designs/PhaseInterpolator/Custom_std_Cells/tg_custom.sch
.subckt tg_custom VOUT VSN VSP VIN VBP VBN
*.PININFO VIN:B VSN:B VOUT:B VSP:B VBN:B VBP:B
M1 VOUT VSN VIN VBN sg13_lv_nmos w=0.15u l=0.13u ng=1 m=1
M2 VOUT VSP VIN VBP sg13_lv_pmos w=0.3u l=0.13u ng=2 m=1
.ends
