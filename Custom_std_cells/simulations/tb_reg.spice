** sch_path: /foss/designs/PhaseInterpolator/Custom_std_cells/tb_reg.sch
**.subckt tb_reg
Vdd1 vdd GND 1.2
Vdd3 vss GND 0
Vdd2 clk GND dc 0 ac 0 pulse(0, 1.2, 0,50p,50p, 335p, 770p)
Vdd4 in GND dc 0 ac 0 pulse(0, 1.2, 250p,50p,50p, 950p, 2n)
x1 vdd clk vss out in reg_v2
**** begin user architecture code

.lib cornerMOSlv.lib mos_tt
*.include /foss/pdks/ihp-sg13g2/libs.ref/sg13g2_stdcell/spice/sg13g2_stdcell.spice

.save v(clk) v(in) v(out)

.tran 5p 6n

.control
run
set color0=white
write tran_logic.raw

.endc

**** end user architecture code
**.ends

* expanding   symbol:  reg_v2.sym # of pins=5
** sym_path: /foss/designs/PhaseInterpolator/Custom_std_cells/reg_v2.sym
** sch_path: /foss/designs/PhaseInterpolator/Custom_std_cells/reg_v2.sch
.subckt reg_v2 VDD CLK VSS Q D
*.iopin VDD
*.iopin VSS
*.ipin CLK
*.ipin D
*.opin Q
x3 net7 CLK CLK_B net2 VDD VSS tg_custom
x9 VDD CLK_B CLK VSS inv
x4 VDD net2 net1 VSS inv
x8 VDD net4 D VSS inv
x11 VDD net3 Q VSS inv
x10 VDD net5 net1 VSS inv
x2 net7 CLK_B CLK net4 VDD VSS tg_custom
x6 net6 CLK_B CLK net3 VDD VSS tg_custom
x7 net6 CLK CLK_B net5 VDD VSS tg_custom
x5 VDD net1 net7 VSS inv
x1 VDD Q net6 VSS inv
.ends

* expanding   symbol:  tg_custom.sym # of pins=6
** sym_path: /foss/designs/PhaseInterpolator/Custom_std_cells/tg_custom.sym
** sch_path: /foss/designs/PhaseInterpolator/Custom_std_cells/tg_custom.sch
.subckt tg_custom VOUT VSN VSP VIN VBP VBN
*.iopin VIN
*.iopin VSN
*.iopin VOUT
*.iopin VSP
*.iopin VBN
*.iopin VBP
XM1 VOUT VSN VIN VBN sg13_lv_nmos w=0.15u l=0.13u ng=1 m=1
XM2 VOUT VSP VIN VBP sg13_lv_pmos w=0.3u l=0.13u ng=2 m=1
.ends

* expanding   symbol:  inv.sym # of pins=4
** sym_path: /foss/designs/PhaseInterpolator/Custom_std_cells/inv.sym
** sch_path: /foss/designs/PhaseInterpolator/Custom_std_cells/inv.sch
.subckt inv VDD VOUT VIN VSS
*.iopin VDD
*.iopin VSS
*.opin VOUT
*.ipin VIN
XM2 VOUT VIN VDD VDD sg13_lv_pmos w=0.15u l=0.13u ng=1 m=1
XM1 VOUT VIN VSS VSS sg13_lv_nmos w=0.15u l=0.13u ng=1 m=1
.ends

.GLOBAL GND
.end
