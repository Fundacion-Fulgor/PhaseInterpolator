** sch_path: /foss/designs/PhaseInterpolator/Custom_std_cells/nor_custom.sch
.subckt nor_custom VDD A OUT B VSS
*.PININFO VDD:B VSS:B A:I B:I OUT:O
M1 OUT A VSS VSS sg13_lv_nmos w=0.15u l=0.13u ng=1 m=1
M2 OUT B net1 VDD sg13_lv_pmos w=0.15u l=0.13u ng=1 m=1
M3 OUT B VSS VSS sg13_lv_nmos w=0.15u l=0.13u ng=1 m=1
M4 net1 A VDD VDD sg13_lv_pmos w=0.15u l=0.13u ng=1 m=1
.ends
