** sch_path: /foss/designs/PhaseInterpolator/Custom_std_cells/nand_custom.sch
.subckt nand_custom VDD OUT A B VSS
*.PININFO VDD:B VSS:B A:I B:I OUT:O
M1 OUT A net1 VSS sg13_lv_nmos w=0.15u l=0.13u ng=1 m=1
M2 OUT A VDD VDD sg13_lv_pmos w=0.15u l=0.13u ng=1 m=1
M3 net1 B VSS VSS sg13_lv_nmos w=0.15u l=0.13u ng=1 m=1
M4 OUT B VDD VDD sg13_lv_pmos w=0.15u l=0.13u ng=1 m=1
.ends
