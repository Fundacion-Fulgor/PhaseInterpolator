** sch_path: /foss/designs/PhaseInterpolator/Custom_std_cells/tb_inv.sch
**.subckt tb_inv
x1 vdd voutx vin vss inv
Vdd1 vdd GND 1.2
Vdd3 vss GND 0
VIN1 vin GND PULSE(0 1.2 0 10p 10p 490p 1n)
**** begin user architecture code

.tran 5p 16n
.save all

.control
run
set color0=white
write inv.raw

.endc

.lib cornerMOSlv.lib mos_tt

.inc /foss/designs/PhaseInterpolator/Custom_std_cells/inv.spice

**** end user architecture code
**.ends
.GLOBAL GND
.end
