** sch_path: /foss/designs/PhaseInterpolator/Custom_std_cells/inv1.sch
.subckt inv1 VDD VSS VOUT VIN
*.PININFO VDD:B VSS:B VOUT:O VIN:I
M2 VOUT VIN VDD VDD sg13_lv_pmos w=0.15u l=0.13u ng=1 m=1
M1 VOUT VIN VSS VSS sg13_lv_nmos w=0.15u l=0.13u ng=1 m=1
.ends
