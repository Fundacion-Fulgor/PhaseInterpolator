** sch_path: /foss/designs/PhaseInterpolator/Custom_std_cells/tieh_custom.sch
.subckt tieh_custom VDD VOUT VSS
*.PININFO VDD:B VSS:B VOUT:O
M2 VOUT net1 VDD VDD sg13_lv_pmos w=0.15u l=0.13u ng=1 m=1
M1 net1 net1 VSS VSS sg13_lv_nmos w=0.15u l=0.13u ng=1 m=1
.ends
