** sch_path: /foss/designs/PhaseInterpolator/Custom_std_cells/inv_xor.sch
**.subckt inv_xor VDD VBP VIN VBN VSS VOUT
*.iopin VDD
*.iopin VSS
*.opin VOUT
*.ipin VIN
*.iopin VBP
*.iopin VBN
XM2 VOUT VIN VDD VBP sg13_lv_pmos w=0.15u l=0.13u ng=1 m=1
XM1 VOUT VIN VSS VBN sg13_lv_nmos w=0.15u l=0.13u ng=1 m=1
**.ends
.end
