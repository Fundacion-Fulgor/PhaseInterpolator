** sch_path: /foss/designs/PhaseInterpolator/Custom_std_cells/div_freq_x2.sch
.subckt div_freq_x2 VDD VSS CLKOUT CLKIN
*.PININFO VDD:B VSS:B CLKIN:I CLKOUT:O
x1 VDD CLKIN CLKOUT net1 VSS reg
x4 VDD net1 CLKOUT VSS inv
.ends

* expanding   symbol:  reg.sym # of pins=5
** sym_path: /foss/designs/PhaseInterpolator/Custom_std_cells/reg.sym
** sch_path: /foss/designs/PhaseInterpolator/Custom_std_cells/reg.sch
.subckt reg VDD CLK Q D VSS
*.PININFO D:I Q:O VDD:B VSS:B CLK:I
M2 X CLK net1 VDD sg13_lv_pmos w=0.15u l=0.13u ng=1 m=1
M1 X CLK_B net2 VSS sg13_lv_nmos w=0.15u l=0.13u ng=1 m=1
M3 net1 D VDD VDD sg13_lv_pmos w=0.15u l=0.13u ng=1 m=1
M4 net2 D VSS VSS sg13_lv_nmos w=0.15u l=0.13u ng=1 m=1
M5 Q CLK_B net3 VDD sg13_lv_pmos w=0.15u l=0.13u ng=1 m=1
M6 Q CLK net4 VSS sg13_lv_nmos w=0.15u l=0.13u ng=1 m=1
M7 net3 X VDD VDD sg13_lv_pmos w=0.15u l=0.13u ng=1 m=1
M8 net4 X VSS VSS sg13_lv_nmos w=0.15u l=0.13u ng=1 m=1
x1 VDD CLK_B CLK VSS inv
.ends

* expanding   symbol:  inv.sym # of pins=4
** sym_path: /foss/designs/PhaseInterpolator/Custom_std_cells/inv.sym
** sch_path: /foss/designs/PhaseInterpolator/Custom_std_cells/inv.sch
.subckt inv VDD VOUT VIN VSS
*.PININFO VDD:B VSS:B VOUT:O VIN:I
M2 VOUT VIN VDD VDD sg13_lv_pmos w=0.15u l=0.13u ng=1 m=1
M1 VOUT VIN VSS VSS sg13_lv_nmos w=0.15u l=0.13u ng=1 m=1
.ends
