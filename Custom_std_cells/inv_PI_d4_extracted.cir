* Extracted by KLayout with SG13G2 LVS runset on : 09/01/2026 19:41

.SUBCKT inv_PI_d4 VSS VDD VOUT VIN
X$1 VSS VOUT VIN inv_PI_d2
X$2 VSS VOUT VIN inv_PI_d2
M$1 VDD VIN VOUT VDD sg13_lv_pmos L=0.13u W=1.8u AS=0.711p AD=0.711p PS=9.48u
+ PD=9.48u
.ENDS inv_PI_d4

.SUBCKT inv_PI_d2 VSS VOUT VIN
M$1 VSS VIN VOUT VSS sg13_lv_nmos L=0.13u W=0.6u AS=0.267p AD=0.267p PS=3.56u
+ PD=3.56u
.ENDS inv_PI_d2
