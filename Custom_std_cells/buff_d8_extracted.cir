* Extracted by KLayout with SG13G2 LVS runset on : 28/02/2026 21:23

.SUBCKT buff_d8 VSS VDD VIN VOUT
X$1 \$1 VSS VDD \$2 inv_d2
X$3 \$3 VSS \$2 VDD inv_d4
X$4 VOUT VSS VDD \$3 inv_d8
M$1 VSS VIN \$1 VSS sg13_lv_nmos L=0.13u W=0.15u AS=0.1005p AD=0.1005p PS=1.34u
+ PD=1.34u
M$2 VDD VIN \$1 VDD sg13_lv_pmos L=0.13u W=0.15u AS=0.1005p AD=0.1005p PS=1.34u
+ PD=1.34u
.ENDS buff_d8

.SUBCKT inv_d8 VOUT VSS VDD VIN
X$1 VOUT VSS VIN VDD inv_d4
X$2 VOUT VSS VIN VDD inv_d4
.ENDS inv_d8

.SUBCKT inv_d4 VOUT VSS VIN VDD
X$1 VIN VSS VDD VOUT inv_d2
X$2 VIN VSS VDD VOUT inv_d2
.ENDS inv_d4

.SUBCKT inv_d2 VIN VSS VDD VOUT
M$1 VSS VIN VOUT VSS sg13_lv_nmos L=0.13u W=0.3u AS=0.156p AD=0.156p PS=2.08u
+ PD=2.08u
M$3 VDD VIN VOUT VDD sg13_lv_pmos L=0.13u W=0.3u AS=0.156p AD=0.156p PS=2.08u
+ PD=2.08u
.ENDS inv_d2
