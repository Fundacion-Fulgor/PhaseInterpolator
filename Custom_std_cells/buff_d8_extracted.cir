* Extracted by KLayout with SG13G2 LVS runset on : 11/01/2026 22:04

.SUBCKT buff_d8 VSS VDD VOUT VIN
X$2 VSS \$8 \$2 VDD inv_d2
X$3 VSS \$3 \$2 VDD inv_d4
X$4 VSS \$3 VOUT VDD inv_d8
M$1 VSS VIN \$8 VSS sg13_lv_nmos L=0.13u W=0.15u AS=0.1005p AD=0.1005p PS=1.34u
+ PD=1.34u
M$2 VDD VIN \$8 VDD sg13_lv_pmos L=0.13u W=0.15u AS=0.1005p AD=0.1005p PS=1.34u
+ PD=1.34u
.ENDS buff_d8

.SUBCKT inv_d8 VSS VIN VOUT VDD
X$1 VSS VOUT VIN VDD inv_d4
X$2 VSS VOUT VIN VDD inv_d4
.ENDS inv_d8

.SUBCKT inv_d4 VSS VOUT VIN VDD
X$1 VSS VIN VOUT VDD inv_d2
X$2 VSS VIN VOUT VDD inv_d2
.ENDS inv_d4

.SUBCKT inv_d2 VSS VIN VOUT VDD
M$1 VSS VIN VOUT VSS sg13_lv_nmos L=0.13u W=0.3u AS=0.156p AD=0.156p PS=2.08u
+ PD=2.08u
M$3 VDD VIN VOUT VDD sg13_lv_pmos L=0.13u W=0.3u AS=0.156p AD=0.156p PS=2.08u
+ PD=2.08u
.ENDS inv_d2
