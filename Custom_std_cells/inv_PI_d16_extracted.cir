* Extracted by KLayout with SG13G2 LVS runset on : 11/01/2026 00:01

.SUBCKT inv_PI_d16 VDD VSS VIN VOUT
X$1 VIN VOUT VSS VDD inv_PI_d8
X$2 VIN VOUT VSS VDD inv_PI_d8
.ENDS inv_PI_d16

.SUBCKT inv_PI_d8 VIN VOUT VSS VDD
X$1 VSS VOUT VIN VDD inv_PI_d4
X$2 VSS VOUT VIN VDD inv_PI_d4
.ENDS inv_PI_d8

.SUBCKT inv_PI_d4 VSS VOUT VIN VDD
X$1 VSS VIN VOUT inv_PI_d2
X$2 VSS VIN VOUT inv_PI_d2
M$1 VDD VIN VOUT VDD sg13_lv_pmos L=0.13u W=1.8u AS=0.711p AD=0.711p PS=9.48u
+ PD=9.48u
.ENDS inv_PI_d4

.SUBCKT inv_PI_d2 VSS VIN VOUT
M$1 VSS VIN VOUT VSS sg13_lv_nmos L=0.13u W=0.6u AS=0.267p AD=0.267p PS=3.56u
+ PD=3.56u
.ENDS inv_PI_d2
