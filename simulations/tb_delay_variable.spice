** sch_path: /foss/designs/PhaseInterpolator/2to4/tb_delay_variable.sch
**.subckt tb_delay_variable
x1 vdd voutn voutp vc vn vp vss dcvsl_variable
Vdd1 vdd GND 1.2
VIN1 vp GND PULSE(0 1.2 0 10p 10p 240p 500p)
VIN2 vn GND PULSE(0 1.2 250p 10p 10p 240p 500p)
Vdd4 vc GND 0.9
Vdd3 vss GND 0
**** begin user architecture code

.lib cornerMOSlv.lib mos_tt
*.include /foss/pdks/ihp-sg13g2/libs.ref/sg13g2_stdcell/spice/sg13g2_stdcell.spice

.save v(vp) v(vn) v(voutn) v(voup)

.tran 5p 3n
.save all

.control
run
set color0=white
write tran_logic.raw

meas tran SKEW0_90 TRIG v(vp) VAL=0.6 RISE=3 TARG v(voutp) VAL=0.6 RISE=2
meas tran SKEW90_180 TRIG v(voutp) VAL=0.6 RISE=2 TARG v(vn) VAL=0.6 RISE=3
meas tran SKEW180_270 TRIG v(vn) VAL=0.6 RISE=3 TARG v(voutn) VAL=0.6 RISE=3
meas tran SKEW270_0 TRIG v(voutn) VAL=0.6 RISE=3 TARG v(vp) VAL=0.6 RISE=4

*meas tran T90 TRIG v(voutp) VAL=0.6 RISE=3 TARG v(v90) VAL=0.6 RISE=4
*meas tran T180 TRIG v(vn) VAL=0.6 RISE=3 TARG v(v180) VAL=0.6 RISE=4
*meas tran T270 TRIG v(voutn) VAL=0.6 RISE=3 TARG v(v270) VAL=0.6 RISE=4
*meas tran T0 TRIG v(vp) VAL=0.6 RISE=3 TARG v(v0) VAL=0.6 RISE=4

let phase0_90 = (SKEW0_90 / 500p) * 360
let phase90_180 = (SKEW90_180 / 500p) * 360
let phase180_270 = (SKEW180_270 / 500p) * 360
let phase270_0 = (SKEW270_0 / 500p) * 360

meas tran PW0 TRIG v(vp) VAL=0.6 RISE=3 TARG v(vp) VAL=0.6 FALL=3
meas tran PW90 TRIG v(voutp) VAL=0.6 RISE=3 TARG v(voutp) VAL=0.6 FALL=4
meas tran PW180 TRIG v(vn) VAL=0.6 RISE=3 TARG v(vn) VAL=0.6 FALL=3
meas tran PW270 TRIG v(voutn) VAL=0.6 RISE=3 TARG v(voutn) VAL=0.6 FALL=4

print SKEW0_90 SKEW90_180 SKEW180_270 SKEW270_0 phase0_90 phase90_180 phase180_270 phase270_0 PW0 PW90 PW180 PW270

.endc

**** end user architecture code
**.ends

* expanding   symbol:  /foss/designs/PhaseInterpolator/2to4/dcvsl_variable.sym # of pins=7
** sym_path: /foss/designs/PhaseInterpolator/2to4/dcvsl_variable.sym
** sch_path: /foss/designs/PhaseInterpolator/2to4/dcvsl_variable.sch
.subckt dcvsl_variable VDD VOUTN VOUTP CTRL CLKN CLKP VSS
*.iopin VSS
*.ipin CLKP
*.ipin CLKN
*.iopin VDD
*.ipin CTRL
*.opin VOUTP
*.opin VOUTN
XM1 VOUTDN CLKP VSS VSS sg13_lv_nmos w=0.15u l=0.13u ng=1 m=30
XM2 VOUTDP CLKN VSS VSS sg13_lv_nmos w=0.15u l=0.13u ng=1 m=30
XM3 net1 CTRL VOUTDN VSS sg13_lv_nmos w=0.15u l=0.13u ng=1 m=2
XM4 net2 CTRL VOUTDP VSS sg13_lv_nmos w=0.15u l=0.13u ng=1 m=2
XM6 VOUTDP net1 VDD VDD sg13_lv_pmos w=0.15u l=0.13u ng=1 m=15
XM5 VOUTDN net2 VDD VDD sg13_lv_pmos w=0.15u l=0.13u ng=1 m=15
XM7 VOUTDN VSS VDD VDD sg13_lv_pmos w=0.15u l=0.13u ng=1 m=20
XM8 VOUTDP VSS VDD VDD sg13_lv_pmos w=0.15u l=0.13u ng=1 m=20
x2 VDD VOUTP VOUTDP vss buff_PI_d16
x3 VDD VOUTN VOUTDN vss buff_PI_d16
C2 VOUTDP VSS 50f m=1
C1 VOUTDN VSS 50f m=1
.ends

* expanding   symbol:  /foss/designs/PhaseInterpolator/Custom_std_cells/buff_PI_d16.sym # of pins=4
** sym_path: /foss/designs/PhaseInterpolator/Custom_std_cells/buff_PI_d16.sym
** sch_path: /foss/designs/PhaseInterpolator/Custom_std_cells/buff_PI_d16.sch
.subckt buff_PI_d16 VDD VOUT VIN VSS
*.ipin VIN
*.opin VOUT
*.iopin VDD
*.iopin VSS
x7 VDD net1 VIN VSS inv_PI_d2
x8 VDD net2 net1 VSS inv_PI_d4
x9 VDD net3 net2 VSS inv_PI_d8
x10 VDD VOUT net3 VSS inv_PI_d16
.ends

* expanding   symbol:  /foss/designs/PhaseInterpolator/Custom_std_cells/inv_PI_d2.sym # of pins=4
** sym_path: /foss/designs/PhaseInterpolator/Custom_std_cells/inv_PI_d2.sym
** sch_path: /foss/designs/PhaseInterpolator/Custom_std_cells/inv_PI_d2.sch
.subckt inv_PI_d2 VDD VOUT VIN VSS
*.ipin VIN
*.opin VOUT
*.iopin VDD
*.iopin VSS
x1[1] VDD VOUT VIN VSS inv_PI
x1[0] VDD VOUT VIN VSS inv_PI
.ends

* expanding   symbol:  /foss/designs/PhaseInterpolator/Custom_std_cells/inv_PI_d4.sym # of pins=4
** sym_path: /foss/designs/PhaseInterpolator/Custom_std_cells/inv_PI_d4.sym
** sch_path: /foss/designs/PhaseInterpolator/Custom_std_cells/inv_PI_d4.sch
.subckt inv_PI_d4 VDD VOUT VIN VSS
*.ipin VIN
*.opin VOUT
*.iopin VDD
*.iopin VSS
x1[1] VDD VOUT VIN VSS inv_PI_d2
x1[0] VDD VOUT VIN VSS inv_PI_d2
.ends

* expanding   symbol:  /foss/designs/PhaseInterpolator/Custom_std_cells/inv_PI_d8.sym # of pins=4
** sym_path: /foss/designs/PhaseInterpolator/Custom_std_cells/inv_PI_d8.sym
** sch_path: /foss/designs/PhaseInterpolator/Custom_std_cells/inv_PI_d8.sch
.subckt inv_PI_d8 VDD VOUT VIN VSS
*.ipin VIN
*.opin VOUT
*.iopin VDD
*.iopin VSS
x1[1] VDD VOUT VIN VSS inv_PI_d4
x1[0] VDD VOUT VIN VSS inv_PI_d4
.ends

* expanding   symbol:  /foss/designs/PhaseInterpolator/Custom_std_cells/inv_PI_d16.sym # of pins=4
** sym_path: /foss/designs/PhaseInterpolator/Custom_std_cells/inv_PI_d16.sym
** sch_path: /foss/designs/PhaseInterpolator/Custom_std_cells/inv_PI_d16.sch
.subckt inv_PI_d16 VDD VOUT VIN VSS
*.ipin VIN
*.opin VOUT
*.iopin VDD
*.iopin VSS
x1[1] VDD VOUT VIN VSS inv_PI_d8
x1[0] VDD VOUT VIN VSS inv_PI_d8
.ends

* expanding   symbol:  /foss/designs/PhaseInterpolator/Custom_std_cells/inv_PI.sym # of pins=4
** sym_path: /foss/designs/PhaseInterpolator/Custom_std_cells/inv_PI.sym
** sch_path: /foss/designs/PhaseInterpolator/Custom_std_cells/inv_PI.sch
.subckt inv_PI VDD VOUT VIN VSS
*.iopin VDD
*.iopin VSS
*.opin VOUT
*.ipin VIN
XM2 VOUT VIN VDD VDD sg13_lv_pmos w=0.45u l=0.13u ng=3 m=1
XM1 VOUT VIN VSS VSS sg13_lv_nmos w=0.3u l=0.13u ng=2 m=1
.ends

.GLOBAL GND
.end
