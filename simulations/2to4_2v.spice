** sch_path: /foss/designs/PhaseInterpolator/2to4/2to4_2v.sch
**.subckt 2to4_2v VDD VINI VCONT VINIB VSS VQ VIB VQB VI
*.ipin VCONT
*.ipin VINI
*.opin VIB
*.opin VQ
*.ipin VINIB
*.opin VI
*.opin VQB
*.iopin VDD
*.iopin VSS
x1 VDD VINI net2 VCONT VSS delay_variable
x2 VDD net1 net2 VSS inv
x3 VDD net4 net1 VSS inv
x6 VDD net3 VINI VSS inv
x8 VDD VIB net3 VSS buff_d16
x9 VDD VQ net4 VSS buff_d16
x11 VDD VINIB net6 VCONT VSS delay_variable
x12 VDD net5 net6 VSS inv
x13 VDD net8 net5 VSS inv
x15 VDD net7 VINIB VSS inv
x16 VDD VI net7 VSS buff_d16
x17 VDD VQB net8 VSS buff_d16
**.ends

* expanding   symbol:  /foss/designs/PhaseInterpolator/2to4/delay_variable.sym # of pins=5
** sym_path: /foss/designs/PhaseInterpolator/2to4/delay_variable.sym
** sch_path: /foss/designs/PhaseInterpolator/2to4/delay_variable.sch
.subckt delay_variable VDD VIN VOUT VCONT VSS
*.iopin VSS
*.iopin VDD
*.opin VOUT
*.ipin VCONT
*.ipin VIN
XM1 VOUT VIN net2 VSS sg13_lv_nmos w=0.15u l=0.13u ng=1 m=4
XM2 net2 VCONT VSS VSS sg13_lv_nmos w=0.15u l=0.25u ng=1 m=4
XM3 net3 VCONT VSS VSS sg13_lv_nmos w=0.15u l=0.25u ng=1 m=5
XM5 VOUT VIN net1 VDD sg13_lv_pmos w=0.2u l=0.13u ng=1 m=5
XM6 net1 net3 VDD VDD sg13_lv_pmos w=0.2u l=0.25u ng=1 m=5
XM4 net3 net3 VDD VDD sg13_lv_pmos w=0.15u l=0.25u ng=1 m=5
.ends

* expanding   symbol:  /foss/designs/PhaseInterpolator/Custom_std_cells/inv.sym # of pins=4
** sym_path: /foss/designs/PhaseInterpolator/Custom_std_cells/inv.sym
** sch_path: /foss/designs/PhaseInterpolator/Custom_std_cells/inv.sch
.subckt inv VDD VOUT VIN VSS
*.iopin VDD
*.iopin VSS
*.opin VOUT
*.ipin VIN
XM2 VOUT VIN VDD VDD sg13_lv_pmos w=0.15u l=0.13u ng=1 m=1
XM1 VOUT VIN VSS VSS sg13_lv_nmos w=0.15u l=0.13u ng=1 m=1
.ends

* expanding   symbol:  /foss/designs/PhaseInterpolator/Custom_std_cells/buff_d16.sym # of pins=4
** sym_path: /foss/designs/PhaseInterpolator/Custom_std_cells/buff_d16.sym
** sch_path: /foss/designs/PhaseInterpolator/Custom_std_cells/buff_d16.sch
.subckt buff_d16 VDD VOUT VIN VSS
*.ipin VIN
*.opin VOUT
*.iopin VDD
*.iopin VSS
x7 VDD net1 VIN VSS inv_d2
x8 VDD net2 net1 VSS inv_d4
x9 VDD net3 net2 VSS inv_d8
x10 VDD VOUT net3 VSS inv_d16
.ends

* expanding   symbol:  /foss/designs/PhaseInterpolator/Custom_std_cells/inv_d2.sym # of pins=4
** sym_path: /foss/designs/PhaseInterpolator/Custom_std_cells/inv_d2.sym
** sch_path: /foss/designs/PhaseInterpolator/Custom_std_cells/inv_d2.sch
.subckt inv_d2 VDD VOUT VIN VSS
*.ipin VIN
*.opin VOUT
*.iopin VDD
*.iopin VSS
x1[1] VDD VOUT VIN VSS inv
x1[0] VDD VOUT VIN VSS inv
.ends

* expanding   symbol:  /foss/designs/PhaseInterpolator/Custom_std_cells/inv_d4.sym # of pins=4
** sym_path: /foss/designs/PhaseInterpolator/Custom_std_cells/inv_d4.sym
** sch_path: /foss/designs/PhaseInterpolator/Custom_std_cells/inv_d4.sch
.subckt inv_d4 VDD VOUT VIN VSS
*.ipin VIN
*.opin VOUT
*.iopin VDD
*.iopin VSS
x1[1] VDD VOUT VIN VSS inv_d2
x1[0] VDD VOUT VIN VSS inv_d2
.ends

* expanding   symbol:  /foss/designs/PhaseInterpolator/Custom_std_cells/inv_d8.sym # of pins=4
** sym_path: /foss/designs/PhaseInterpolator/Custom_std_cells/inv_d8.sym
** sch_path: /foss/designs/PhaseInterpolator/Custom_std_cells/inv_d8.sch
.subckt inv_d8 VDD VOUT VIN VSS
*.ipin VIN
*.opin VOUT
*.iopin VDD
*.iopin VSS
x1[1] VDD VOUT VIN VSS inv_d4
x1[0] VDD VOUT VIN VSS inv_d4
.ends

* expanding   symbol:  /foss/designs/PhaseInterpolator/Custom_std_cells/inv_d16.sym # of pins=4
** sym_path: /foss/designs/PhaseInterpolator/Custom_std_cells/inv_d16.sym
** sch_path: /foss/designs/PhaseInterpolator/Custom_std_cells/inv_d16.sch
.subckt inv_d16 VDD VOUT VIN VSS
*.ipin VIN
*.opin VOUT
*.iopin VDD
*.iopin VSS
x1[1] VDD VOUT VIN VSS inv_d8
x1[0] VDD VOUT VIN VSS inv_d8
.ends

.end
